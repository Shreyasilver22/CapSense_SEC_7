* Exact used SCL CDL cells, unchanged transistor definitions.

.subckt ADNR00 IN2 IN1 IN3 OUT1 VDD GROUND
M0 7 IN2 VDD VDD P L=8e-07 W=5.8e-06 AD=1.856e-11 AS=2.46e-11 PD=1.8e-05
+ PS=2.12e-05 NRD=0.189655 NRS=0.281609
M1 VDD IN1 7 VDD P L=8e-07 W=5.8e-06 AD=2.74e-11 AS=1.856e-11 PD=2.2e-05
+ PS=1.8e-05 NRD=0.237069 NRS=0.275862
M2 OUT1 IN3 7 VDD P L=8e-07 W=5.8e-06 AD=1.682e-11 AS=1.682e-11 PD=1.74e-05
+ PS=1.74e-05 NRD=0.218391 NRS=0.275862
M3 11 IN2 GROUND GROUND N L=8e-07 W=2.9e-06 AD=1.45e-12 AS=8.41e-12 PD=3.9e-06
+ PS=1.16e-05 NRD=0.172414 NRS=0.551724
M4 OUT1 IN1 11 GROUND N L=8e-07 W=2.9e-06 AD=9.28e-12 AS=1.45e-12 PD=1.22e-05
+ PS=3.9e-06 NRD=0.551724 NRS=0.172414
M5 GROUND IN3 OUT1 GROUND N L=8e-07 W=2.9e-06 AD=8.41e-12 AS=9.28e-12
+ PD=1.16e-05 PS=1.22e-05 NRD=0.37931 NRS=0.551724
.ends ADNR00

.subckt AND200 IN2 IN1 OUT1 GROUND VDD
M0 5 IN2 VDD VDD P L=8e-07 W=3.1e-06 AD=9.92e-12 AS=8.99e-12 PD=1.26e-05
+ PS=1.2e-05 NRD=0.354839 NRS=0.516129
M1 VDD IN1 5 VDD P L=8e-07 W=3.1e-06 AD=9.87e-12 AS=9.92e-12 PD=1.26e-05
+ PS=1.26e-05 NRD=0.354839 NRS=0.516129
M2 OUT1 5 VDD VDD P L=8e-07 W=3e-06 AD=8.7e-12 AS=9.87e-12 PD=1.18e-05
+ PS=1.26e-05 NRD=0.366667 NRS=0.533333
M3 10 IN2 GROUND GROUND N L=8e-07 W=2.4e-06 AD=2.16e-12 AS=7.96e-12 PD=4.2e-06
+ PS=1.14e-05 NRD=0.375 NRS=0.75
M4 5 IN1 10 GROUND N L=8e-07 W=2.4e-06 AD=7.96e-12 AS=2.16e-12 PD=1.14e-05
+ PS=4.2e-06 NRD=0.75 NRS=0.375
M5 OUT1 5 GROUND GROUND N L=8e-07 W=2e-06 AD=7.76e-12 AS=7.76e-12 PD=1.14e-05
+ PS=1.14e-05 NRD=0.6 NRS=0.9
.ends AND200

.subckt AND300 IN3 IN2 IN1 OUT1 GROUND VDD
M0 VDD IN3 7 VDD P L=8e-07 W=3e-06 AD=9.75e-12 AS=8.85e-12 PD=1.25e-05
+ PS=1.19e-05 NRD=0.375 NRS=0.55
M1 7 IN2 VDD VDD P L=8e-07 W=3e-06 AD=9.6e-12 AS=9.75e-12 PD=1.24e-05
+ PS=1.25e-05 NRD=0.366667 NRS=0.533333
M2 VDD IN1 7 VDD P L=8e-07 W=3e-06 AD=9.6e-12 AS=9.6e-12 PD=1.24e-05 PS=1.24e-05
+ NRD=0.366667 NRS=0.533333
M3 OUT1 7 VDD VDD P L=8e-07 W=3e-06 AD=8.7e-12 AS=9.6e-12 PD=1.18e-05
+ PS=1.24e-05 NRD=0.366667 NRS=0.533333
M4 12 IN3 GROUND GROUND N L=8e-07 W=3e-06 AD=6e-12 AS=8.85e-12 PD=7e-06
+ PS=1.19e-05 NRD=0.666667 NRS=0.55
M5 13 IN2 12 GROUND N L=8e-07 W=3e-06 AD=1.95e-12 AS=6e-12 PD=4.3e-06 PS=7e-06
+ NRD=0.216667 NRS=0.666667
M6 7 IN1 13 GROUND N L=8e-07 W=3e-06 AD=1.02e-11 AS=1.95e-12 PD=1.28e-05
+ PS=4.3e-06 NRD=0.7 NRS=0.216667
M7 OUT1 7 GROUND GROUND N L=8e-07 W=2e-06 AD=7.76e-12 AS=7.76e-12 PD=1.14e-05
+ PS=1.14e-05 NRD=0.6 NRS=0.9
.ends AND300

.subckt AND500 IN5 IN4 IN3 IN2 IN1 OUT1 GROUND VDD
M0 9 IN5 VDD VDD P L=8e-07 W=6e-06 AD=1.92e-11 AS=1.74e-11 PD=1.84e-05
+ PS=1.78e-05 NRD=0.211111 NRS=0.266667
M1 VDD IN4 9 VDD P L=8e-07 W=6e-06 AD=1.92e-11 AS=1.92e-11 PD=1.84e-05
+ PS=1.84e-05 NRD=0.211111 NRS=0.266667
M2 9 IN3 VDD VDD P L=8e-07 W=6e-06 AD=2.22e-11 AS=1.92e-11 PD=1.94e-05
+ PS=1.84e-05 NRD=0.211111 NRS=0.266667
M3 VDD IN2 9 VDD P L=8e-07 W=6e-06 AD=1.98e-11 AS=2.22e-11 PD=1.86e-05
+ PS=1.94e-05 NRD=0.222222 NRS=0.35
M4 9 IN1 VDD VDD P L=8e-07 W=6e-06 AD=1.74e-11 AS=1.98e-11 PD=1.78e-05
+ PS=1.86e-05 NRD=0.211111 NRS=0.266667
M5 VDD 9 OUT1 VDD P L=8e-07 W=3e-06 AD=8.7e-12 AS=8.7e-12 PD=1.18e-05
+ PS=1.18e-05 NRD=0.366667 NRS=0.533333
M6 16 IN5 GROUND GROUND N L=8e-07 W=5.3e-06 AD=6.36e-12 AS=1.537e-11 PD=7.7e-06
+ PS=1.64e-05 NRD=0.226415 NRS=0.301887
M7 17 IN4 16 GROUND N L=8e-07 W=5.3e-06 AD=8.215e-12 AS=6.36e-12 PD=8.4e-06
+ PS=7.7e-06 NRD=0.292453 NRS=0.226415
M8 18 IN3 17 GROUND N L=8e-07 W=5.3e-06 AD=1.961e-11 AS=8.215e-12 PD=1.27e-05
+ PS=8.4e-06 NRD=0.698113 NRS=0.292453
M9 19 IN2 18 GROUND N L=8e-07 W=5.3e-06 AD=3.445e-12 AS=1.961e-11 PD=6.6e-06
+ PS=1.27e-05 NRD=0.122642 NRS=0.698113
M10 9 IN1 19 GROUND N L=8e-07 W=5.3e-06 AD=2.31e-11 AS=3.445e-12 PD=2.11e-05
+ PS=6.6e-06 NRD=0.330189 NRS=0.122642
M11 OUT1 9 GROUND GROUND N L=8e-07 W=2e-06 AD=7.76e-12 AS=7.76e-12 PD=1.14e-05
+ PS=1.14e-05 NRD=0.6 NRS=0.9
.ends AND500

.subckt DFCL11 C D CLR QB Q GROUND VDD
M0 VDD C 11 VDD P L=8e-07 W=3e-06 AD=9.6e-12 AS=8.7e-12 PD=1.24e-05 PS=1.18e-05
+ NRD=0.366667 NRS=0.533333
M1 12 11 VDD VDD P L=8e-07 W=3e-06 AD=8.7e-12 AS=9.6e-12 PD=1.18e-05 PS=1.24e-05
+ NRD=0.366667 NRS=0.533333
M2 3 12 D VDD P L=8e-07 W=3e-06 AD=1.05e-11 AS=8.7e-12 PD=1.3e-05 PS=1.18e-05
+ NRD=0.391667 NRS=0.533333
M3 4 11 3 VDD P L=8e-07 W=3e-06 AD=1.08e-11 AS=1.05e-11 PD=1.32e-05 PS=1.3e-05
+ NRD=0.408333 NRS=0.583333
M4 VDD 6 4 VDD P L=8e-07 W=3e-06 AD=8.7e-12 AS=1.08e-11 PD=1.18e-05 PS=1.32e-05
+ NRD=0.366667 NRS=0.583333
M5 VDD CLR 6 VDD P L=8e-07 W=3e-06 AD=9.6e-12 AS=8.7e-12 PD=1.24e-05 PS=1.18e-05
+ NRD=0.366667 NRS=0.533333
M6 6 3 VDD VDD P L=8e-07 W=3e-06 AD=1.08e-11 AS=9.6e-12 PD=1.32e-05 PS=1.24e-05
+ NRD=0.391667 NRS=0.533333
M7 7 11 6 VDD P L=8e-07 W=3e-06 AD=1.08e-11 AS=1.08e-11 PD=1.32e-05 PS=1.32e-05
+ NRD=0.391667 NRS=0.616667
M8 8 12 7 VDD P L=8e-07 W=3e-06 AD=1.05e-11 AS=1.08e-11 PD=1.3e-05 PS=1.32e-05
+ NRD=0.391667 NRS=0.616667
M9 VDD 13 8 VDD P L=8e-07 W=3e-06 AD=9.6e-12 AS=1.05e-11 PD=1.24e-05 PS=1.3e-05
+ NRD=0.366667 NRS=0.583333
M10 8 CLR VDD VDD P L=8e-07 W=3e-06 AD=8.7e-12 AS=9.6e-12 PD=1.18e-05
+ PS=1.24e-05 NRD=0.366667 NRS=0.533333
M11 13 7 VDD VDD P L=8e-07 W=3e-06 AD=8.7e-12 AS=8.7e-12 PD=1.18e-05 PS=1.18e-05
+ NRD=0.366667 NRS=0.533333
M12 VDD 13 QB VDD P L=8e-07 W=4.4e-06 AD=1.441e-11 AS=1.276e-11 PD=1.56e-05
+ PS=1.46e-05 NRD=0.25 NRS=0.363636
M13 Q QB VDD VDD P L=8e-07 W=4.6e-06 AD=1.334e-11 AS=1.441e-11 PD=1.5e-05
+ PS=1.56e-05 NRD=0.23913 NRS=0.347826
M14 GROUND C 11 GROUND N L=8e-07 W=2e-06 AD=8.24e-12 AS=7.5e-12 PD=1.2e-05
+ PS=1.12e-05 NRD=0.575 NRS=0.85
M15 12 11 GROUND GROUND N L=8e-07 W=2e-06 AD=7.5e-12 AS=8.24e-12 PD=1.12e-05
+ PS=1.2e-05 NRD=0.575 NRS=0.85
M16 3 11 D GROUND N L=8e-07 W=2e-06 AD=8.76e-12 AS=7.5e-12 PD=1.24e-05
+ PS=1.12e-05 NRD=0.6 NRS=0.85
M17 4 12 3 GROUND N L=8e-07 W=2e-06 AD=3.056e-11 AS=8.76e-12 PD=2.34e-05
+ PS=1.24e-05 NRD=0.9 NRS=0.9
M18 GROUND 6 4 GROUND N L=8e-07 W=2e-06 AD=2.236e-11 AS=3.056e-11 PD=2.42e-05
+ PS=2.34e-05 NRD=0.9 NRS=0.9
M19 29 CLR GROUND GROUND N L=8e-07 W=2e-06 AD=3.2e-12 AS=2.236e-11 PD=5.2e-06
+ PS=2.42e-05 NRD=0.8 NRS=0.9
M20 6 3 29 GROUND N L=8e-07 W=2e-06 AD=8.76e-12 AS=3.2e-12 PD=1.24e-05
+ PS=5.2e-06 NRD=0.9 NRS=0.8
M21 7 12 6 GROUND N L=8e-07 W=2e-06 AD=8.76e-12 AS=8.76e-12 PD=1.24e-05
+ PS=1.24e-05 NRD=0.6 NRS=0.9
M22 8 11 7 GROUND N L=8e-07 W=2e-06 AD=2.92e-11 AS=8.76e-12 PD=2.3e-05
+ PS=1.24e-05 NRD=0.9 NRS=0.9
M23 30 13 8 GROUND N L=8e-07 W=2e-06 AD=4.6e-12 AS=2.92e-11 PD=6.6e-06
+ PS=2.3e-05 NRD=1.15 NRS=0.9
M24 GROUND CLR 30 GROUND N L=8e-07 W=2e-06 AD=1.962e-11 AS=4.6e-12 PD=2.14e-05
+ PS=6.6e-06 NRD=0.9 NRS=1.15
M25 13 7 GROUND GROUND N L=8e-07 W=2e-06 AD=7.76e-12 AS=1.962e-11 PD=1.14e-05
+ PS=2.14e-05 NRD=0.9 NRS=0.9
M26 GROUND 13 QB GROUND N L=8e-07 W=2.4e-06 AD=9.16e-12 AS=7.96e-12 PD=1.24e-05
+ PS=1.14e-05 NRD=0.5 NRS=0.75
M27 Q QB GROUND GROUND N L=8e-07 W=2.4e-06 AD=7.96e-12 AS=9.16e-12 PD=1.14e-05
+ PS=1.24e-05 NRD=0.5 NRS=0.75
.ends DFCL11

.subckt DFPR11 C D PRB QB Q GROUND VDD
M0 VDD C 11 VDD P L=8e-07 W=3.3e-06 AD=1.04e-11 AS=9.57e-12 PD=1.3e-05
+ PS=1.24e-05 NRD=0.333333 NRS=0.484848
M1 12 11 VDD VDD P L=8e-07 W=3.2e-06 AD=9.28e-12 AS=1.04e-11 PD=1.22e-05
+ PS=1.3e-05 NRD=0.34375 NRS=0.5
M2 3 12 D VDD P L=8e-07 W=4e-06 AD=1.35e-11 AS=1.16e-11 PD=1.5e-05 PS=1.38e-05
+ NRD=0.29375 NRS=0.4
M3 4 11 3 VDD P L=8e-07 W=3e-06 AD=1.111e-11 AS=1.35e-11 PD=1.34e-05 PS=1.5e-05
+ NRD=0.408333 NRS=0.583333
M4 VDD 6 4 VDD P L=8e-07 W=3.1e-06 AD=9.92e-12 AS=1.111e-11 PD=1.26e-05
+ PS=1.34e-05 NRD=0.354839 NRS=0.564516
M5 4 PRB VDD VDD P L=8e-07 W=3.1e-06 AD=8.99e-12 AS=9.92e-12 PD=1.2e-05
+ PS=1.26e-05 NRD=0.354839 NRS=0.516129
M6 6 3 VDD VDD P L=8e-07 W=3e-06 AD=1.08e-11 AS=8.7e-12 PD=1.32e-05 PS=1.18e-05
+ NRD=0.391667 NRS=0.533333
M7 7 11 6 VDD P L=8e-07 W=3e-06 AD=1.08e-11 AS=1.08e-11 PD=1.32e-05 PS=1.32e-05
+ NRD=0.391667 NRS=0.616667
M8 8 12 7 VDD P L=8e-07 W=3e-06 AD=1.05e-11 AS=1.08e-11 PD=1.3e-05 PS=1.32e-05
+ NRD=0.391667 NRS=0.616667
M9 VDD 13 8 VDD P L=8e-07 W=3e-06 AD=8.7e-12 AS=1.05e-11 PD=1.18e-05 PS=1.3e-05
+ NRD=0.366667 NRS=0.583333
M10 VDD PRB 13 VDD P L=8e-07 W=3.1e-06 AD=9.92e-12 AS=8.99e-12 PD=1.26e-05
+ PS=1.2e-05 NRD=0.354839 NRS=0.516129
M11 13 7 VDD VDD P L=8e-07 W=3.1e-06 AD=8.99e-12 AS=9.92e-12 PD=1.2e-05
+ PS=1.26e-05 NRD=0.354839 NRS=0.516129
M12 VDD 13 QB VDD P L=8e-07 W=4.4e-06 AD=1.434e-11 AS=1.276e-11 PD=1.54e-05
+ PS=1.46e-05 NRD=0.25 NRS=0.363636
M13 Q QB VDD VDD P L=8e-07 W=4.5e-06 AD=1.305e-11 AS=1.434e-11 PD=1.48e-05
+ PS=1.54e-05 NRD=0.244444 NRS=0.355556
M14 GROUND C 11 GROUND N L=8e-07 W=2e-06 AD=8.24e-12 AS=7.5e-12 PD=1.2e-05
+ PS=1.12e-05 NRD=0.575 NRS=0.85
M15 12 11 GROUND GROUND N L=8e-07 W=2e-06 AD=7.5e-12 AS=8.24e-12 PD=1.12e-05
+ PS=1.2e-05 NRD=0.575 NRS=0.85
M16 3 11 D GROUND N L=8e-07 W=2e-06 AD=8.76e-12 AS=7.5e-12 PD=1.24e-05
+ PS=1.12e-05 NRD=0.6 NRS=0.85
M17 4 12 3 GROUND N L=8e-07 W=2e-06 AD=3.076e-11 AS=8.76e-12 PD=2.34e-05
+ PS=1.24e-05 NRD=0.9 NRS=0.9
M18 29 6 4 GROUND N L=8e-07 W=2.4e-06 AD=2.88e-12 AS=3.076e-11 PD=4.8e-06
+ PS=2.34e-05 NRD=0.5 NRS=0.75
M19 GROUND PRB 29 GROUND N L=8e-07 W=2.4e-06 AD=2.794e-11 AS=2.88e-12
+ PD=2.76e-05 PS=4.8e-06 NRD=0.75 NRS=0.5
M20 6 3 GROUND GROUND N L=8e-07 W=2.2e-06 AD=8.86e-12 AS=2.794e-11 PD=1.24e-05
+ PS=2.76e-05 NRD=0.818182 NRS=0.818182
M21 7 12 6 GROUND N L=8e-07 W=2e-06 AD=8.76e-12 AS=8.86e-12 PD=1.24e-05
+ PS=1.24e-05 NRD=0.6 NRS=0.9
M22 8 11 7 GROUND N L=8e-07 W=2e-06 AD=2.77e-11 AS=8.76e-12 PD=2.24e-05
+ PS=1.24e-05 NRD=0.9 NRS=0.9
M23 GROUND 13 8 GROUND N L=8e-07 W=2e-06 AD=1.806e-11 AS=2.77e-11 PD=1.94e-05
+ PS=2.24e-05 NRD=0.9 NRS=0.9
M24 30 PRB GROUND GROUND N L=8e-07 W=2.4e-06 AD=4.8e-12 AS=1.806e-11 PD=6.4e-06
+ PS=1.94e-05 NRD=0.833333 NRS=0.75
M25 13 7 30 GROUND N L=8e-07 W=2.4e-06 AD=7.96e-12 AS=4.8e-12 PD=1.14e-05
+ PS=6.4e-06 NRD=0.75 NRS=0.833333
M26 GROUND 13 QB GROUND N L=8e-07 W=2.4e-06 AD=9.16e-12 AS=7.96e-12 PD=1.24e-05
+ PS=1.14e-05 NRD=0.5 NRS=0.75
M27 Q QB GROUND GROUND N L=8e-07 W=2.4e-06 AD=7.96e-12 AS=9.16e-12 PD=1.14e-05
+ PS=1.24e-05 NRD=0.5 NRS=0.75
.ends DFPR11

.subckt INVR00 IN1 OUT1 GROUND VDD
M0 OUT1 IN1 VDD VDD P L=8e-07 W=3e-06 AD=9.3e-12 AS=8.7e-12 PD=1.22e-05
+ PS=1.18e-05 NRD=0.4 NRS=0.533333
M1 OUT1 IN1 GROUND GROUND N L=8e-07 W=2e-06 AD=7.76e-12 AS=7.76e-12 PD=1.14e-05
+ PS=1.14e-05 NRD=0.6 NRS=0.9
.ends INVR00

.subckt NND200 IN2 IN1 OUT1 GROUND VDD
M0 OUT1 IN2 VDD VDD P L=8e-07 W=3.1e-06 AD=9.92e-12 AS=8.99e-12 PD=1.26e-05
+ PS=1.2e-05 NRD=0.354839 NRS=0.516129
M1 VDD IN1 OUT1 VDD P L=8e-07 W=3.1e-06 AD=8.99e-12 AS=9.92e-12 PD=1.2e-05
+ PS=1.26e-05 NRD=0.354839 NRS=0.516129
M2 8 IN2 GROUND GROUND N L=8e-07 W=2.4e-06 AD=2.16e-12 AS=7.96e-12 PD=4.2e-06
+ PS=1.14e-05 NRD=0.375 NRS=0.75
M3 OUT1 IN1 8 GROUND N L=8e-07 W=2.4e-06 AD=1.72e-11 AS=2.16e-12 PD=1.91e-05
+ PS=4.2e-06 NRD=2.35417 NRS=0.375
.ends NND200

.subckt NND300 IN3 IN2 IN1 OUT1 GROUND VDD
M0 VDD IN3 OUT1 VDD P L=8e-07 W=3e-06 AD=9.75e-12 AS=8.85e-12 PD=1.25e-05
+ PS=1.19e-05 NRD=0.375 NRS=0.55
M1 OUT1 IN2 VDD VDD P L=8e-07 W=3e-06 AD=9.6e-12 AS=9.75e-12 PD=1.24e-05
+ PS=1.25e-05 NRD=0.366667 NRS=0.533333
M2 VDD IN1 OUT1 VDD P L=8e-07 W=3e-06 AD=8.7e-12 AS=9.6e-12 PD=1.18e-05
+ PS=1.24e-05 NRD=0.366667 NRS=0.533333
M3 10 IN3 GROUND GROUND N L=8e-07 W=3e-06 AD=6e-12 AS=8.85e-12 PD=7e-06
+ PS=1.19e-05 NRD=0.666667 NRS=0.55
M4 11 IN2 10 GROUND N L=8e-07 W=3e-06 AD=2.625e-12 AS=6e-12 PD=4.75e-06 PS=7e-06
+ NRD=0.291667 NRS=0.666667
M5 OUT1 IN1 11 GROUND N L=8e-07 W=3e-06 AD=8.85e-12 AS=2.625e-12 PD=1.19e-05
+ PS=4.75e-06 NRD=0.55 NRS=0.291667
.ends NND300

.subckt NND400 IN4 IN3 IN2 IN1 OUT1 GROUND VDD
M0 VDD IN4 OUT1 VDD P L=8e-07 W=4.8e-06 AD=1.536e-11 AS=1.392e-11 PD=1.6e-05
+ PS=1.54e-05 NRD=0.263889 NRS=0.333333
M1 OUT1 IN3 VDD VDD P L=8e-07 W=4.8e-06 AD=1.536e-11 AS=1.536e-11 PD=1.6e-05
+ PS=1.6e-05 NRD=0.263889 NRS=0.333333
M2 VDD IN2 OUT1 VDD P L=8e-07 W=4.8e-06 AD=1.824e-11 AS=1.536e-11 PD=1.72e-05
+ PS=1.6e-05 NRD=0.263889 NRS=0.333333
M3 OUT1 IN1 VDD VDD P L=8e-07 W=4.8e-06 AD=1.392e-11 AS=1.824e-11 PD=1.54e-05
+ PS=1.72e-05 NRD=0.263889 NRS=0.458333
M4 12 IN4 GROUND GROUND N L=8e-07 W=4e-06 AD=4.9e-12 AS=1.16e-11 PD=6.45e-06
+ PS=1.38e-05 NRD=0.30625 NRS=0.4
M5 13 IN3 12 GROUND N L=8e-07 W=4e-06 AD=7.5e-12 AS=4.9e-12 PD=7.75e-06
+ PS=6.45e-06 NRD=0.46875 NRS=0.30625
M6 14 IN2 13 GROUND N L=8e-07 W=4e-06 AD=3e-12 AS=7.5e-12 PD=5.5e-06 PS=7.75e-06
+ NRD=0.1875 NRS=0.46875
M7 OUT1 IN1 14 GROUND N L=8e-07 W=4e-06 AD=1.32e-11 AS=3e-12 PD=1.46e-05
+ PS=5.5e-06 NRD=0.45 NRS=0.1875
.ends NND400

.subckt NOR200 IN1 IN2 OUT1 VDD GROUND
M0 8 IN1 VDD VDD P L=8e-07 W=5.3e-06 AD=4.9025e-12 AS=1.537e-11 PD=7.15e-06
+ PS=1.64e-05 NRD=0.174528 NRS=0.301887
M1 OUT1 IN2 8 VDD P L=8e-07 W=5.3e-06 AD=1.537e-11 AS=4.9025e-12 PD=1.64e-05
+ PS=7.15e-06 NRD=0.301887 NRS=0.174528
M2 OUT1 IN1 GROUND GROUND N L=8e-07 W=2.1e-06 AD=1.25e-11 AS=7.81e-12
+ PD=1.52e-05 PS=1.14e-05 NRD=0.857143 NRS=0.857143
M3 GROUND IN2 OUT1 GROUND N L=8e-07 W=2.1e-06 AD=9.37e-12 AS=1.25e-11
+ PD=1.26e-05 PS=1.52e-05 NRD=0.619048 NRS=0.857143
.ends NOR200

.subckt NOR300 IN1 IN2 IN3 OUT1 VDD GROUND
M0 10 IN1 VDD VDD P L=8e-07 W=8.5e-06 AD=8.5e-12 AS=2.661e-11 PD=1.05e-05
+ PS=2.34e-05 NRD=0.117647 NRS=0.211765
M1 11 IN2 10 VDD P L=8e-07 W=8.5e-06 AD=1.6575e-11 AS=8.5e-12 PD=1.24e-05
+ PS=1.05e-05 NRD=0.229412 NRS=0.117647
M2 OUT1 IN3 11 VDD P L=8e-07 W=8.5e-06 AD=3.23e-11 AS=1.6575e-11 PD=2.46e-05
+ PS=1.24e-05 NRD=0.247059 NRS=0.229412
M3 OUT1 IN1 GROUND GROUND N L=8e-07 W=2.6e-06 AD=1.365e-11 AS=7.54e-12
+ PD=1.57e-05 PS=1.1e-05 NRD=0.365385 NRS=0.615385
M4 GROUND IN2 OUT1 GROUND N L=8e-07 W=2.6e-06 AD=8.32e-12 AS=1.365e-11
+ PD=1.16e-05 PS=1.57e-05 NRD=0.615385 NRS=0.489231
M5 OUT1 IN3 GROUND GROUND N L=8e-07 W=2.6e-06 AD=1.17e-11 AS=8.32e-12
+ PD=1.42e-05 PS=1.16e-05 NRD=0.365385 NRS=0.615385
.ends NOR300

.subckt OR2100 IN2 IN1 OUT1 GROUND VDD
M0 10 IN2 VDD VDD P L=8e-07 W=3.6e-06 AD=3.15e-12 AS=1.044e-11 PD=5.35e-06
+ PS=1.3e-05 NRD=0.243056 NRS=0.444444
M1 5 IN1 10 VDD P L=8e-07 W=3.6e-06 AD=1.044e-11 AS=3.15e-12 PD=1.3e-05
+ PS=5.35e-06 NRD=0.444444 NRS=0.243056
M2 OUT1 5 VDD VDD P L=8e-07 W=3.1e-06 AD=8.99e-12 AS=8.99e-12 PD=1.2e-05
+ PS=1.2e-05 NRD=0.354839 NRS=0.516129
M3 5 IN2 GROUND GROUND N L=8e-07 W=2e-06 AD=1.24e-11 AS=7.76e-12 PD=1.52e-05
+ PS=1.14e-05 NRD=0.9 NRS=0.9
M4 GROUND IN1 5 GROUND N L=8e-07 W=2e-06 AD=8.76e-12 AS=1.24e-11 PD=1.24e-05
+ PS=1.52e-05 NRD=0.9 NRS=0.9
M5 OUT1 5 GROUND GROUND N L=8e-07 W=2e-06 AD=1.14e-11 AS=8.76e-12 PD=1.42e-05
+ PS=1.24e-05 NRD=0.9 NRS=0.9
.ends OR2100

.subckt OR3100 IN1 IN2 IN3 OUT1 GROUND VDD
M0 12 IN1 VDD VDD P L=8e-07 W=8.5e-06 AD=8.5e-12 AS=2.465e-11 PD=1.05e-05
+ PS=2.28e-05 NRD=0.117647 NRS=0.188235
M1 13 IN2 12 VDD P L=8e-07 W=8.5e-06 AD=1.12625e-11 AS=8.5e-12 PD=1.115e-05
+ PS=1.05e-05 NRD=0.155882 NRS=0.117647
M2 6 IN3 13 VDD P L=8e-07 W=8.5e-06 AD=3.23e-11 AS=1.12625e-11 PD=2.46e-05
+ PS=1.115e-05 NRD=0.188235 NRS=0.155882
M3 OUT1 6 VDD VDD P L=8e-07 W=3.1e-06 AD=8.99e-12 AS=8.99e-12 PD=1.2e-05
+ PS=1.2e-05 NRD=0.354839 NRS=0.516129
M4 6 IN1 GROUND GROUND N L=8e-07 W=2.6e-06 AD=1.365e-11 AS=7.54e-12 PD=1.57e-05
+ PS=1.1e-05 NRD=0.365385 NRS=0.615385
M5 GROUND IN2 6 GROUND N L=8e-07 W=2.6e-06 AD=8.32e-12 AS=1.365e-11 PD=1.16e-05
+ PS=1.57e-05 NRD=0.615385 NRS=0.489231
M6 6 IN3 GROUND GROUND N L=8e-07 W=2.6e-06 AD=1.17e-11 AS=8.32e-12 PD=1.42e-05
+ PS=1.16e-05 NRD=0.365385 NRS=0.615385
M7 OUT1 6 GROUND GROUND N L=8e-07 W=2e-06 AD=7.76e-12 AS=7.76e-12 PD=1.14e-05
+ PS=1.14e-05 NRD=0.6 NRS=0.9
.ends OR3100

.subckt ORND00 IN3 IN2 IN1 OUT1 GROUND VDD
M0 OUT1 IN3 VDD VDD P L=8e-07 W=4.1e-06 AD=1.558e-11 AS=1.189e-11 PD=1.58e-05
+ PS=1.4e-05 NRD=0.268293 NRS=0.390244
M1 11 IN2 OUT1 VDD P L=8e-07 W=4.1e-06 AD=2.05e-12 AS=1.558e-11 PD=5.1e-06
+ PS=1.58e-05 NRD=0.121951 NRS=0.536585
M2 VDD IN1 11 VDD P L=8e-07 W=4.1e-06 AD=1.189e-11 AS=2.05e-12 PD=1.4e-05
+ PS=5.1e-06 NRD=0.390244 NRS=0.121951
M3 12 IN2 OUT1 GROUND N L=8e-07 W=2.7e-06 AD=5.22e-12 AS=8.76e-12 PD=5.66667e-06
+ PS=1.19e-05 NRD=1.07407 NRS=0.666667
M4 12 IN3 GROUND GROUND N L=8e-07 W=2.7e-06 AD=5.22e-12 AS=7.83e-12
+ PD=5.66667e-06 PS=1.12e-05 NRD=1.07407 NRS=0.592593
M5 OUT1 IN1 12 GROUND N L=8e-07 W=2.7e-06 AD=8.235e-12 AS=5.22e-12 PD=1.15e-05
+ PS=5.66667e-06 NRD=0.648148 NRS=1.07407
.ends ORND00

.subckt XOR200 IN1 OUT1 IN2 GROUND VDD
M0 5 IN1 VDD VDD P L=8e-07 W=3e-06 AD=8.7e-12 AS=8.7e-12 PD=1.18e-05 PS=1.18e-05
+ NRD=0.366667 NRS=0.533333
M1 7 IN1 6 VDD P L=8e-07 W=3e-06 AD=1.05e-11 AS=8.7e-12 PD=1.3e-05 PS=1.18e-05
+ NRD=0.366667 NRS=0.533333
M2 2 5 7 VDD P L=8e-07 W=3e-06 AD=8.7e-12 AS=1.05e-11 PD=1.18e-05 PS=1.3e-05
+ NRD=0.366667 NRS=0.633333
M3 2 6 VDD VDD P L=8e-07 W=3e-06 AD=8.7e-12 AS=8.7e-12 PD=1.18e-05 PS=1.18e-05
+ NRD=0.366667 NRS=0.533333
M4 OUT1 7 VDD VDD P L=8e-07 W=3.1e-06 AD=8.99e-12 AS=8.99e-12 PD=1.2e-05
+ PS=1.2e-05 NRD=0.354839 NRS=0.516129
M5 VDD IN2 6 VDD P L=8e-07 W=3e-06 AD=8.7e-12 AS=8.7e-12 PD=1.18e-05 PS=1.18e-05
+ NRD=0.366667 NRS=0.533333
M6 5 IN1 GROUND GROUND N L=8e-07 W=2e-06 AD=7.76e-12 AS=7.76e-12 PD=1.14e-05
+ PS=1.14e-05 NRD=0.6 NRS=0.9
M7 7 5 6 GROUND N L=8e-07 W=2e-06 AD=8.76e-12 AS=7.76e-12 PD=1.24e-05
+ PS=1.14e-05 NRD=0.6 NRS=0.9
M8 2 IN1 7 GROUND N L=8e-07 W=2e-06 AD=7.76e-12 AS=8.76e-12 PD=1.14e-05
+ PS=1.24e-05 NRD=0.6 NRS=0.9
M9 2 6 GROUND GROUND N L=8e-07 W=2e-06 AD=7.76e-12 AS=7.76e-12 PD=1.14e-05
+ PS=1.14e-05 NRD=0.6 NRS=0.9
M10 OUT1 7 GROUND GROUND N L=8e-07 W=2e-06 AD=7.76e-12 AS=7.76e-12 PD=1.14e-05
+ PS=1.14e-05 NRD=0.6 NRS=0.9
M11 6 IN2 GROUND GROUND N L=8e-07 W=2e-06 AD=1.01e-11 AS=8.02e-12 PD=1.32e-05
+ PS=1.16e-05 NRD=0.475 NRS=0.925
.ends XOR200
