.SUBCKT CAPSENSE_PHASE_GEN GROUND VDD CLK_1MHZ PHI1 PHI1B PHI2 PHI2B PHIT PHITB RST_N SAMPLE_VALID

X_050_ COUNT[2] _005_ GROUND VDD INVR00
X_051_ COUNT[1] _006_ GROUND VDD INVR00
X_052_ COUNT[0] NEXT_COUNT[0] GROUND VDD INVR00
X_053_ _004_ _007_ GROUND VDD INVR00
X_054_ COUNT[5] _008_ GROUND VDD INVR00
X_055_ COUNT[4] _009_ GROUND VDD INVR00
X_056_ COUNT[0] COUNT[1] _010_ GROUND VDD AND200
X_057_ _010_ COUNT[2] _011_ GROUND VDD NND200
X_058_ COUNT[0] COUNT[1] COUNT[2] COUNT[3] _012_ GROUND VDD NND400
X_059_ _004_ _012_ _013_ VDD GROUND NOR200
X_060_ _013_ COUNT[5] _014_ GROUND VDD OR2100
X_061_ COUNT[6] _009_ COUNT[5] _015_ GROUND VDD NND300
X_062_ COUNT[3] COUNT[2] _016_ VDD GROUND NOR200
X_063_ _016_ _010_ _017_ GROUND VDD NND200
X_064_ _017_ _015_ _018_ GROUND VDD OR2100
X_065_ _013_ COUNT[5] _019_ GROUND VDD NND200
X_066_ _019_ _018_ _014_ NEXT_COUNT[5] GROUND VDD AND300
X_067_ _010_ COUNT[2] _020_ GROUND VDD OR2100
X_068_ _018_ _011_ _021_ GROUND VDD NND200
X_069_ _020_ _018_ _011_ NEXT_COUNT[2] GROUND VDD AND300
X_070_ _007_ _022_ _012_ GROUND VDD XNR200
X_071_ _022_ _017_ _015_ _023_ GROUND VDD ORND00
X_072_ _023_ NEXT_COUNT[4] GROUND VDD INVR00
X_073_ COUNT[1] COUNT[0] _024_ VDD GROUND NOR200
X_074_ _010_ _024_ NEXT_COUNT[1] VDD GROUND NOR200
X_075_ COUNT[4] COUNT[5] _025_ GROUND VDD NND200
X_076_ _012_ _025_ _026_ VDD GROUND NOR200
X_077_ _026_ COUNT[6] _027_ GROUND VDD OR2100
X_078_ _026_ COUNT[6] _028_ GROUND VDD NND200
X_079_ _028_ _027_ _018_ _029_ GROUND VDD NND300
X_080_ _029_ NEXT_COUNT[6] GROUND VDD INVR00
X_081_ _011_ COUNT[3] _030_ GROUND VDD NND200
X_082_ _030_ _023_ _031_ GROUND VDD NND200
X_083_ _031_ NEXT_COUNT[5] NEXT_COUNT[6] _000_ VDD GROUND ADNR00
X_084_ _011_ COUNT[3] _032_ GROUND VDD OR2100
X_085_ _032_ _030_ NEXT_COUNT[3] GROUND VDD NND200
X_086_ COUNT[5] _023_ _033_ VDD GROUND NOR200
X_087_ _033_ _032_ NEXT_COUNT[6] _021_ _003_ GROUND VDD AND400
X_088_ _018_ _011_ _008_ _007_ COUNT[3] _034_ GROUND VDD AND500
X_089_ _034_ NEXT_COUNT[5] _035_ GROUND VDD OR2100
X_090_ NEXT_COUNT[0] _006_ _005_ COUNT[3] _036_ GROUND VDD AND400
X_091_ _036_ _033_ _029_ _037_ VDD GROUND ADNR00
X_092_ COUNT[2] COUNT[3] _038_ GROUND VDD NND200
X_093_ _023_ _038_ _010_ _039_ GROUND VDD ORND00
X_094_ _039_ NEXT_COUNT[5] _040_ GROUND VDD NND200
X_095_ _035_ _037_ _029_ _040_ _002_ VDD GROUND AOI400
X_096_ NEXT_COUNT[1] _020_ _011_ COUNT[3] _041_ GROUND VDD AND400
X_097_ NEXT_COUNT[5] _041_ NEXT_COUNT[4] _042_ GROUND VDD ORND00
X_098_ _035_ _037_ _029_ _042_ _001_ VDD GROUND AOI400
X_099_ CLKNET_1_1__LEAF_CLK_1MHZ _000_ RST_N PHI1B PHI1 GROUND VDD DFCL11
X_100_ CLKNET_1_1__LEAF_CLK_1MHZ _002_ RST_N PHITB PHIT GROUND VDD DFCL11
X_101_ CLKNET_1_1__LEAF_CLK_1MHZ _001_ RST_N PHI2B PHI2 GROUND VDD DFCL11
X_102_ CLKNET_1_1__LEAF_CLK_1MHZ _003_ RST_N _044_ SAMPLE_VALID GROUND VDD DFCL11
X_103_ CLKNET_1_0__LEAF_CLK_1MHZ NEXT_COUNT[0] RST_N _045_ COUNT[0] GROUND VDD DFPR11
X_104_ CLKNET_1_0__LEAF_CLK_1MHZ NEXT_COUNT[1] RST_N _046_ COUNT[1] GROUND VDD DFPR11
X_105_ CLKNET_1_0__LEAF_CLK_1MHZ NEXT_COUNT[2] RST_N _047_ COUNT[2] GROUND VDD DFCL11
X_106_ CLKNET_1_0__LEAF_CLK_1MHZ NEXT_COUNT[3] RST_N _048_ COUNT[3] GROUND VDD DFCL11
X_107_ CLKNET_1_0__LEAF_CLK_1MHZ NEXT_COUNT[4] RST_N _004_ COUNT[4] GROUND VDD DFCL11
X_108_ CLKNET_1_1__LEAF_CLK_1MHZ NEXT_COUNT[5] RST_N _049_ COUNT[5] GROUND VDD DFPR11
X_109_ CLKNET_1_1__LEAF_CLK_1MHZ NEXT_COUNT[6] RST_N _043_ COUNT[6] GROUND VDD DFPR11
XCLKBUF_0_CLK_1MHZ CLK_1MHZ CLKNET_0_CLK_1MHZ GROUND VDD BUFF00
XCLKBUF_1_0__F_CLK_1MHZ CLKNET_0_CLK_1MHZ CLKNET_1_0__LEAF_CLK_1MHZ GROUND VDD BUFF00
XCLKBUF_1_1__F_CLK_1MHZ CLKNET_0_CLK_1MHZ CLKNET_1_1__LEAF_CLK_1MHZ GROUND VDD BUFF00
XFILLER_0_0_0 GROUND VDD FILLER1
XFILLER_0_0_32 GROUND VDD FILLER1
XFILLER_0_0_64 GROUND VDD FILLER1
XFILLER_0_0_96 GROUND VDD FILLER1
XFILLER_0_0_128 GROUND VDD FILLER1
XFILLER_0_0_160 GROUND VDD FILLER1
XFILLER_0_0_192 GROUND VDD FILLER5
XFILLER_0_2_0 GROUND VDD FILLER1
XFILLER_0_2_32 GROUND VDD FILLER1
XFILLER_0_2_64 GROUND VDD FILLER1
XFILLER_0_2_96 GROUND VDD FILLER1
XFILLER_0_2_128 GROUND VDD FILLER1
XFILLER_0_2_160 GROUND VDD FILLER1
XFILLER_0_2_192 GROUND VDD FILLER5
XFILLER_0_4_0 GROUND VDD FILLER1
XFILLER_0_4_32 GROUND VDD FILLER1
XFILLER_0_4_64 GROUND VDD FILLER1
XFILLER_0_4_96 GROUND VDD FILLER1
XFILLER_0_4_128 GROUND VDD FILLER1
XFILLER_0_4_160 GROUND VDD FILLER1
XFILLER_0_4_192 GROUND VDD FILLER5
XFILLER_0_6_0 GROUND VDD FILLER1
XFILLER_0_6_32 GROUND VDD FILLER1
XFILLER_0_6_64 GROUND VDD FILLER1
XFILLER_0_6_96 GROUND VDD FILLER1
XFILLER_0_6_128 GROUND VDD FILLER1
XFILLER_0_6_160 GROUND VDD FILLER1
XFILLER_0_6_192 GROUND VDD FILLER5
XFILLER_0_8_0 GROUND VDD FILLER1
XFILLER_0_8_32 GROUND VDD FILLER1
XFILLER_0_8_64 GROUND VDD FILLER1
XFILLER_0_8_96 GROUND VDD FILLER3
XFILLER_0_8_104 GROUND VDD FILLER6
XFILLER_0_8_127 GROUND VDD FILLER1
XFILLER_0_8_159 GROUND VDD FILLER1
XFILLER_0_8_191 GROUND VDD FILLER5
XFILLER_0_8_193 GROUND VDD FILLER6
XFILLER_0_10_0 GROUND VDD FILLER1
XFILLER_0_10_32 GROUND VDD FILLER1
XFILLER_0_10_64 GROUND VDD FILLER5
XFILLER_0_10_66 GROUND VDD FILLER6
XFILLER_0_10_89 GROUND VDD FILLER2
XFILLER_0_10_105 GROUND VDD FILLER3
XFILLER_0_10_113 GROUND VDD FILLER6
XFILLER_0_10_123 GROUND VDD FILLER4
XFILLER_0_10_127 GROUND VDD FILLER5
XFILLER_0_10_129 GROUND VDD FILLER6
XFILLER_0_10_138 GROUND VDD FILLER3
XFILLER_0_10_146 GROUND VDD FILLER4
XFILLER_0_10_150 GROUND VDD FILLER5
XFILLER_0_10_152 GROUND VDD FILLER6
XFILLER_0_10_175 GROUND VDD FILLER2
XFILLER_0_10_191 GROUND VDD FILLER5
XFILLER_0_10_193 GROUND VDD FILLER6
XFILLER_0_12_0 GROUND VDD FILLER1
XFILLER_0_12_32 GROUND VDD FILLER4
XFILLER_0_12_36 GROUND VDD FILLER5
XFILLER_0_12_60 GROUND VDD FILLER2
XFILLER_0_12_76 GROUND VDD FILLER3
XFILLER_0_12_84 GROUND VDD FILLER4
XFILLER_0_12_95 GROUND VDD FILLER2
XFILLER_0_12_111 GROUND VDD FILLER5
XFILLER_0_12_117 GROUND VDD FILLER5
XFILLER_0_12_127 GROUND VDD FILLER3
XFILLER_0_12_135 GROUND VDD FILLER4
XFILLER_0_12_139 GROUND VDD FILLER6
XFILLER_0_12_147 GROUND VDD FILLER2
XFILLER_0_12_163 GROUND VDD FILLER5
XFILLER_0_12_165 GROUND VDD FILLER6
XFILLER_0_12_188 GROUND VDD FILLER4
XFILLER_0_12_192 GROUND VDD FILLER5
XFILLER_0_14_0 GROUND VDD FILLER1
XFILLER_0_14_32 GROUND VDD FILLER2
XFILLER_0_14_48 GROUND VDD FILLER4
XFILLER_0_14_52 GROUND VDD FILLER5
XFILLER_0_14_57 GROUND VDD FILLER3
XFILLER_0_14_65 GROUND VDD FILLER6
XFILLER_0_14_77 GROUND VDD FILLER2
XFILLER_0_14_93 GROUND VDD FILLER4
XFILLER_0_14_97 GROUND VDD FILLER6
XFILLER_0_14_102 GROUND VDD FILLER1
XFILLER_0_14_134 GROUND VDD FILLER1
XFILLER_0_14_166 GROUND VDD FILLER2
XFILLER_0_14_182 GROUND VDD FILLER3
XFILLER_0_14_190 GROUND VDD FILLER4
XFILLER_0_16_0 GROUND VDD FILLER1
XFILLER_0_16_32 GROUND VDD FILLER2
XFILLER_0_16_48 GROUND VDD FILLER3
XFILLER_0_16_56 GROUND VDD FILLER4
XFILLER_0_16_60 GROUND VDD FILLER6
XFILLER_0_16_64 GROUND VDD FILLER5
XFILLER_0_16_70 GROUND VDD FILLER3
XFILLER_0_16_78 GROUND VDD FILLER4
XFILLER_0_16_82 GROUND VDD FILLER6
XFILLER_0_16_96 GROUND VDD FILLER5
XFILLER_0_16_98 GROUND VDD FILLER6
XFILLER_0_16_109 GROUND VDD FILLER2
XFILLER_0_16_125 GROUND VDD FILLER5
XFILLER_0_16_127 GROUND VDD FILLER6
XFILLER_0_16_135 GROUND VDD FILLER2
XFILLER_0_16_151 GROUND VDD FILLER3
XFILLER_0_16_159 GROUND VDD FILLER4
XFILLER_0_16_163 GROUND VDD FILLER5
XFILLER_0_16_165 GROUND VDD FILLER6
XFILLER_0_16_188 GROUND VDD FILLER4
XFILLER_0_16_192 GROUND VDD FILLER5
XFILLER_0_18_0 GROUND VDD FILLER1
XFILLER_0_18_32 GROUND VDD FILLER5
XFILLER_0_18_56 GROUND VDD FILLER6
XFILLER_0_18_78 GROUND VDD FILLER5
XFILLER_0_18_88 GROUND VDD FILLER6
XFILLER_0_18_97 GROUND VDD FILLER3
XFILLER_0_18_114 GROUND VDD FILLER3
XFILLER_0_18_136 GROUND VDD FILLER6
XFILLER_0_18_153 GROUND VDD FILLER3
XFILLER_0_18_161 GROUND VDD FILLER4
XFILLER_0_18_165 GROUND VDD FILLER6
XFILLER_0_18_188 GROUND VDD FILLER4
XFILLER_0_18_192 GROUND VDD FILLER5
XFILLER_0_20_0 GROUND VDD FILLER1
XFILLER_0_20_32 GROUND VDD FILLER1
XFILLER_0_20_64 GROUND VDD FILLER1
XFILLER_0_20_96 GROUND VDD FILLER3
XFILLER_0_20_104 GROUND VDD FILLER5
XFILLER_0_20_106 GROUND VDD FILLER6
XFILLER_0_20_110 GROUND VDD FILLER2
XFILLER_0_20_126 GROUND VDD FILLER6
XFILLER_0_20_132 GROUND VDD FILLER1
XFILLER_0_20_164 GROUND VDD FILLER2
XFILLER_0_20_180 GROUND VDD FILLER3
XFILLER_0_20_188 GROUND VDD FILLER4
XFILLER_0_20_192 GROUND VDD FILLER5
XFILLER_0_22_0 GROUND VDD FILLER1
XFILLER_0_22_32 GROUND VDD FILLER1
XFILLER_0_22_64 GROUND VDD FILLER1
XFILLER_0_22_96 GROUND VDD FILLER2
XFILLER_0_22_112 GROUND VDD FILLER4
XFILLER_0_22_119 GROUND VDD FILLER2
XFILLER_0_22_135 GROUND VDD FILLER4
XFILLER_0_22_139 GROUND VDD FILLER5
XFILLER_0_22_144 GROUND VDD FILLER1
XFILLER_0_22_176 GROUND VDD FILLER2
XFILLER_0_22_192 GROUND VDD FILLER5
XFILLER_0_24_0 GROUND VDD FILLER1
XFILLER_0_24_32 GROUND VDD FILLER2
XFILLER_0_24_48 GROUND VDD FILLER4
XFILLER_0_24_52 GROUND VDD FILLER6
XFILLER_0_24_95 GROUND VDD FILLER5
XFILLER_0_24_108 GROUND VDD FILLER4
XFILLER_0_24_112 GROUND VDD FILLER6
XFILLER_0_24_117 GROUND VDD FILLER5
XFILLER_0_24_132 GROUND VDD FILLER4
XFILLER_0_24_136 GROUND VDD FILLER5
XFILLER_0_24_138 GROUND VDD FILLER6
XFILLER_0_24_183 GROUND VDD FILLER3
XFILLER_0_24_191 GROUND VDD FILLER5
XFILLER_0_24_193 GROUND VDD FILLER6
XFILLER_0_26_0 GROUND VDD FILLER1
XFILLER_0_26_32 GROUND VDD FILLER1
XFILLER_0_26_64 GROUND VDD FILLER2
XFILLER_0_26_80 GROUND VDD FILLER4
XFILLER_0_26_88 GROUND VDD FILLER6
XFILLER_0_26_92 GROUND VDD FILLER5
XFILLER_0_26_94 GROUND VDD FILLER6
XFILLER_0_26_103 GROUND VDD FILLER3
XFILLER_0_26_125 GROUND VDD FILLER1
XFILLER_0_26_157 GROUND VDD FILLER1
XFILLER_0_26_189 GROUND VDD FILLER4
XFILLER_0_26_193 GROUND VDD FILLER6
XFILLER_0_28_0 GROUND VDD FILLER1
XFILLER_0_28_32 GROUND VDD FILLER1
XFILLER_0_28_64 GROUND VDD FILLER1
XFILLER_0_28_96 GROUND VDD FILLER1
XFILLER_0_28_128 GROUND VDD FILLER1
XFILLER_0_28_160 GROUND VDD FILLER1
XFILLER_0_28_192 GROUND VDD FILLER5

.ENDS CAPSENSE_PHASE_GEN

.subckt INVR00 IN1 OUT1 GROUND VDD
M0 OUT1 IN1 VDD VDD P L=8e-07 W=3e-06 AD=9.3e-12 AS=8.7e-12 PD=1.22e-05
+ PS=1.18e-05 NRD=0.4 NRS=0.533333
M1 OUT1 IN1 GROUND GROUND N L=8e-07 W=2e-06 AD=7.76e-12 AS=7.76e-12 PD=1.14e-05
+ PS=1.14e-05 NRD=0.6 NRS=0.9
.ends

.subckt AND200 IN2 IN1 OUT1 GROUND VDD
M0 5 IN2 VDD VDD P L=8e-07 W=3.1e-06 AD=9.92e-12 AS=8.99e-12 PD=1.26e-05
+ PS=1.2e-05 NRD=0.354839 NRS=0.516129
M1 VDD IN1 5 VDD P L=8e-07 W=3.1e-06 AD=9.87e-12 AS=9.92e-12 PD=1.26e-05
+ PS=1.26e-05 NRD=0.354839 NRS=0.516129
M2 OUT1 5 VDD VDD P L=8e-07 W=3e-06 AD=8.7e-12 AS=9.87e-12 PD=1.18e-05
+ PS=1.26e-05 NRD=0.366667 NRS=0.533333
M3 10 IN2 GROUND GROUND N L=8e-07 W=2.4e-06 AD=2.16e-12 AS=7.96e-12 PD=4.2e-06
+ PS=1.14e-05 NRD=0.375 NRS=0.75
M4 5 IN1 10 GROUND N L=8e-07 W=2.4e-06 AD=7.96e-12 AS=2.16e-12 PD=1.14e-05
+ PS=4.2e-06 NRD=0.75 NRS=0.375
M5 OUT1 5 GROUND GROUND N L=8e-07 W=2e-06 AD=7.76e-12 AS=7.76e-12 PD=1.14e-05
+ PS=1.14e-05 NRD=0.6 NRS=0.9
.ends

.subckt NND200 IN2 IN1 OUT1 GROUND VDD
M0 OUT1 IN2 VDD VDD P L=8e-07 W=3.1e-06 AD=9.92e-12 AS=8.99e-12 PD=1.26e-05
+ PS=1.2e-05 NRD=0.354839 NRS=0.516129
M1 VDD IN1 OUT1 VDD P L=8e-07 W=3.1e-06 AD=8.99e-12 AS=9.92e-12 PD=1.2e-05
+ PS=1.26e-05 NRD=0.354839 NRS=0.516129
M2 8 IN2 GROUND GROUND N L=8e-07 W=2.4e-06 AD=2.16e-12 AS=7.96e-12 PD=4.2e-06
+ PS=1.14e-05 NRD=0.375 NRS=0.75
M3 OUT1 IN1 8 GROUND N L=8e-07 W=2.4e-06 AD=1.72e-11 AS=2.16e-12 PD=1.91e-05
+ PS=4.2e-06 NRD=2.35417 NRS=0.375
.ends

.subckt NND400 IN4 IN3 IN2 IN1 OUT1 GROUND VDD
M0 VDD IN4 OUT1 VDD P L=8e-07 W=4.8e-06 AD=1.536e-11 AS=1.392e-11 PD=1.6e-05
+ PS=1.54e-05 NRD=0.263889 NRS=0.333333
M1 OUT1 IN3 VDD VDD P L=8e-07 W=4.8e-06 AD=1.536e-11 AS=1.536e-11 PD=1.6e-05
+ PS=1.6e-05 NRD=0.263889 NRS=0.333333
M2 VDD IN2 OUT1 VDD P L=8e-07 W=4.8e-06 AD=1.824e-11 AS=1.536e-11 PD=1.72e-05
+ PS=1.6e-05 NRD=0.263889 NRS=0.333333
M3 OUT1 IN1 VDD VDD P L=8e-07 W=4.8e-06 AD=1.392e-11 AS=1.824e-11 PD=1.54e-05
+ PS=1.72e-05 NRD=0.263889 NRS=0.458333
M4 12 IN4 GROUND GROUND N L=8e-07 W=4e-06 AD=4.9e-12 AS=1.16e-11 PD=6.45e-06
+ PS=1.38e-05 NRD=0.30625 NRS=0.4
M5 13 IN3 12 GROUND N L=8e-07 W=4e-06 AD=7.5e-12 AS=4.9e-12 PD=7.75e-06
+ PS=6.45e-06 NRD=0.46875 NRS=0.30625
M6 14 IN2 13 GROUND N L=8e-07 W=4e-06 AD=3e-12 AS=7.5e-12 PD=5.5e-06 PS=7.75e-06
+ NRD=0.1875 NRS=0.46875
M7 OUT1 IN1 14 GROUND N L=8e-07 W=4e-06 AD=1.32e-11 AS=3e-12 PD=1.46e-05
+ PS=5.5e-06 NRD=0.45 NRS=0.1875
.ends

.subckt NOR200 IN1 IN2 OUT1 VDD GROUND
M0 8 IN1 VDD VDD P L=8e-07 W=5.3e-06 AD=4.9025e-12 AS=1.537e-11 PD=7.15e-06
+ PS=1.64e-05 NRD=0.174528 NRS=0.301887
M1 OUT1 IN2 8 VDD P L=8e-07 W=5.3e-06 AD=1.537e-11 AS=4.9025e-12 PD=1.64e-05
+ PS=7.15e-06 NRD=0.301887 NRS=0.174528
M2 OUT1 IN1 GROUND GROUND N L=8e-07 W=2.1e-06 AD=1.25e-11 AS=7.81e-12
+ PD=1.52e-05 PS=1.14e-05 NRD=0.857143 NRS=0.857143
M3 GROUND IN2 OUT1 GROUND N L=8e-07 W=2.1e-06 AD=9.37e-12 AS=1.25e-11
+ PD=1.26e-05 PS=1.52e-05 NRD=0.619048 NRS=0.857143
.ends

.subckt OR2100 IN2 IN1 OUT1 GROUND VDD
M0 10 IN2 VDD VDD P L=8e-07 W=3.6e-06 AD=3.15e-12 AS=1.044e-11 PD=5.35e-06
+ PS=1.3e-05 NRD=0.243056 NRS=0.444444
M1 5 IN1 10 VDD P L=8e-07 W=3.6e-06 AD=1.044e-11 AS=3.15e-12 PD=1.3e-05
+ PS=5.35e-06 NRD=0.444444 NRS=0.243056
M2 OUT1 5 VDD VDD P L=8e-07 W=3.1e-06 AD=8.99e-12 AS=8.99e-12 PD=1.2e-05
+ PS=1.2e-05 NRD=0.354839 NRS=0.516129
M3 5 IN2 GROUND GROUND N L=8e-07 W=2e-06 AD=1.24e-11 AS=7.76e-12 PD=1.52e-05
+ PS=1.14e-05 NRD=0.9 NRS=0.9
M4 GROUND IN1 5 GROUND N L=8e-07 W=2e-06 AD=8.76e-12 AS=1.24e-11 PD=1.24e-05
+ PS=1.52e-05 NRD=0.9 NRS=0.9
M5 OUT1 5 GROUND GROUND N L=8e-07 W=2e-06 AD=1.14e-11 AS=8.76e-12 PD=1.42e-05
+ PS=1.24e-05 NRD=0.9 NRS=0.9
.ends

.subckt NND300 IN3 IN2 IN1 OUT1 GROUND VDD
M0 VDD IN3 OUT1 VDD P L=8e-07 W=3e-06 AD=9.75e-12 AS=8.85e-12 PD=1.25e-05
+ PS=1.19e-05 NRD=0.375 NRS=0.55
M1 OUT1 IN2 VDD VDD P L=8e-07 W=3e-06 AD=9.6e-12 AS=9.75e-12 PD=1.24e-05
+ PS=1.25e-05 NRD=0.366667 NRS=0.533333
M2 VDD IN1 OUT1 VDD P L=8e-07 W=3e-06 AD=8.7e-12 AS=9.6e-12 PD=1.18e-05
+ PS=1.24e-05 NRD=0.366667 NRS=0.533333
M3 10 IN3 GROUND GROUND N L=8e-07 W=3e-06 AD=6e-12 AS=8.85e-12 PD=7e-06
+ PS=1.19e-05 NRD=0.666667 NRS=0.55
M4 11 IN2 10 GROUND N L=8e-07 W=3e-06 AD=2.625e-12 AS=6e-12 PD=4.75e-06 PS=7e-06
+ NRD=0.291667 NRS=0.666667
M5 OUT1 IN1 11 GROUND N L=8e-07 W=3e-06 AD=8.85e-12 AS=2.625e-12 PD=1.19e-05
+ PS=4.75e-06 NRD=0.55 NRS=0.291667
.ends

.subckt AND300 IN3 IN2 IN1 OUT1 GROUND VDD
M0 VDD IN3 7 VDD P L=8e-07 W=3e-06 AD=9.75e-12 AS=8.85e-12 PD=1.25e-05
+ PS=1.19e-05 NRD=0.375 NRS=0.55
M1 7 IN2 VDD VDD P L=8e-07 W=3e-06 AD=9.6e-12 AS=9.75e-12 PD=1.24e-05
+ PS=1.25e-05 NRD=0.366667 NRS=0.533333
M2 VDD IN1 7 VDD P L=8e-07 W=3e-06 AD=9.6e-12 AS=9.6e-12 PD=1.24e-05 PS=1.24e-05
+ NRD=0.366667 NRS=0.533333
M3 OUT1 7 VDD VDD P L=8e-07 W=3e-06 AD=8.7e-12 AS=9.6e-12 PD=1.18e-05
+ PS=1.24e-05 NRD=0.366667 NRS=0.533333
M4 12 IN3 GROUND GROUND N L=8e-07 W=3e-06 AD=6e-12 AS=8.85e-12 PD=7e-06
+ PS=1.19e-05 NRD=0.666667 NRS=0.55
M5 13 IN2 12 GROUND N L=8e-07 W=3e-06 AD=1.95e-12 AS=6e-12 PD=4.3e-06 PS=7e-06
+ NRD=0.216667 NRS=0.666667
M6 7 IN1 13 GROUND N L=8e-07 W=3e-06 AD=1.02e-11 AS=1.95e-12 PD=1.28e-05
+ PS=4.3e-06 NRD=0.7 NRS=0.216667
M7 OUT1 7 GROUND GROUND N L=8e-07 W=2e-06 AD=7.76e-12 AS=7.76e-12 PD=1.14e-05
+ PS=1.14e-05 NRD=0.6 NRS=0.9
.ends

.subckt XNR200 IN1 OUT1 IN2 GROUND VDD
M0 5 IN1 VDD VDD P L=8e-07 W=3e-06 AD=8.7e-12 AS=8.7e-12 PD=1.18e-05 PS=1.18e-05
+ NRD=0.366667 NRS=0.533333
M1 7 5 6 VDD P L=8e-07 W=3e-06 AD=1.05e-11 AS=8.7e-12 PD=1.3e-05 PS=1.18e-05
+ NRD=0.366667 NRS=0.533333
M2 2 IN1 7 VDD P L=8e-07 W=3e-06 AD=8.7e-12 AS=1.05e-11 PD=1.18e-05 PS=1.3e-05
+ NRD=0.366667 NRS=0.633333
M3 2 6 VDD VDD P L=8e-07 W=3e-06 AD=8.7e-12 AS=8.7e-12 PD=1.18e-05 PS=1.18e-05
+ NRD=0.366667 NRS=0.533333
M4 OUT1 7 VDD VDD P L=8e-07 W=3e-06 AD=8.7e-12 AS=8.7e-12 PD=1.18e-05
+ PS=1.18e-05 NRD=0.366667 NRS=0.533333
M5 VDD IN2 6 VDD P L=8e-07 W=3e-06 AD=8.7e-12 AS=8.7e-12 PD=1.18e-05 PS=1.18e-05
+ NRD=0.366667 NRS=0.533333
M6 5 IN1 GROUND GROUND N L=8e-07 W=2e-06 AD=7.76e-12 AS=7.76e-12 PD=1.14e-05
+ PS=1.14e-05 NRD=0.6 NRS=0.9
M7 7 IN1 6 GROUND N L=8e-07 W=2e-06 AD=8.76e-12 AS=7.76e-12 PD=1.24e-05
+ PS=1.14e-05 NRD=0.6 NRS=0.9
M8 2 5 7 GROUND N L=8e-07 W=2e-06 AD=7.76e-12 AS=8.76e-12 PD=1.14e-05
+ PS=1.24e-05 NRD=0.6 NRS=0.9
M9 2 6 GROUND GROUND N L=8e-07 W=2e-06 AD=7.76e-12 AS=7.76e-12 PD=1.14e-05
+ PS=1.14e-05 NRD=0.6 NRS=0.9
M10 OUT1 7 GROUND GROUND N L=8e-07 W=2e-06 AD=7.76e-12 AS=7.76e-12 PD=1.14e-05
+ PS=1.14e-05 NRD=0.6 NRS=0.9
M11 6 IN2 GROUND GROUND N L=8e-07 W=2e-06 AD=1.01e-11 AS=8.02e-12 PD=1.32e-05
+ PS=1.16e-05 NRD=0.475 NRS=0.925
.ends

.subckt ORND00 IN3 IN2 IN1 OUT1 GROUND VDD
M0 OUT1 IN3 VDD VDD P L=8e-07 W=4.1e-06 AD=1.558e-11 AS=1.189e-11 PD=1.58e-05
+ PS=1.4e-05 NRD=0.268293 NRS=0.390244
M1 11 IN2 OUT1 VDD P L=8e-07 W=4.1e-06 AD=2.05e-12 AS=1.558e-11 PD=5.1e-06
+ PS=1.58e-05 NRD=0.121951 NRS=0.536585
M2 VDD IN1 11 VDD P L=8e-07 W=4.1e-06 AD=1.189e-11 AS=2.05e-12 PD=1.4e-05
+ PS=5.1e-06 NRD=0.390244 NRS=0.121951
M3 12 IN2 OUT1 GROUND N L=8e-07 W=2.7e-06 AD=5.22e-12 AS=8.76e-12 PD=5.66667e-06
+ PS=1.19e-05 NRD=1.07407 NRS=0.666667
M4 12 IN3 GROUND GROUND N L=8e-07 W=2.7e-06 AD=5.22e-12 AS=7.83e-12
+ PD=5.66667e-06 PS=1.12e-05 NRD=1.07407 NRS=0.592593
M5 OUT1 IN1 12 GROUND N L=8e-07 W=2.7e-06 AD=8.235e-12 AS=5.22e-12 PD=1.15e-05
+ PS=5.66667e-06 NRD=0.648148 NRS=1.07407
.ends

.subckt ADNR00 IN2 IN1 IN3 OUT1 VDD GROUND
M0 7 IN2 VDD VDD P L=8e-07 W=5.8e-06 AD=1.856e-11 AS=2.46e-11 PD=1.8e-05
+ PS=2.12e-05 NRD=0.189655 NRS=0.281609
M1 VDD IN1 7 VDD P L=8e-07 W=5.8e-06 AD=2.74e-11 AS=1.856e-11 PD=2.2e-05
+ PS=1.8e-05 NRD=0.237069 NRS=0.275862
M2 OUT1 IN3 7 VDD P L=8e-07 W=5.8e-06 AD=1.682e-11 AS=1.682e-11 PD=1.74e-05
+ PS=1.74e-05 NRD=0.218391 NRS=0.275862
M3 11 IN2 GROUND GROUND N L=8e-07 W=2.9e-06 AD=1.45e-12 AS=8.41e-12 PD=3.9e-06
+ PS=1.16e-05 NRD=0.172414 NRS=0.551724
M4 OUT1 IN1 11 GROUND N L=8e-07 W=2.9e-06 AD=9.28e-12 AS=1.45e-12 PD=1.22e-05
+ PS=3.9e-06 NRD=0.551724 NRS=0.172414
M5 GROUND IN3 OUT1 GROUND N L=8e-07 W=2.9e-06 AD=8.41e-12 AS=9.28e-12
+ PD=1.16e-05 PS=1.22e-05 NRD=0.37931 NRS=0.551724
.ends

.subckt AND400 IN4 IN3 IN2 IN1 OUT1 GROUND VDD
M0 VDD IN4 8 VDD P L=8e-07 W=4.8e-06 AD=1.536e-11 AS=1.392e-11 PD=1.6e-05
+ PS=1.54e-05 NRD=0.263889 NRS=0.333333
M1 8 IN3 VDD VDD P L=8e-07 W=4.8e-06 AD=1.536e-11 AS=1.536e-11 PD=1.6e-05
+ PS=1.6e-05 NRD=0.263889 NRS=0.333333
M2 VDD IN2 8 VDD P L=8e-07 W=4.8e-06 AD=1.824e-11 AS=1.536e-11 PD=1.72e-05
+ PS=1.6e-05 NRD=0.263889 NRS=0.333333
M3 8 IN1 VDD VDD P L=8e-07 W=4.8e-06 AD=1.392e-11 AS=1.824e-11 PD=1.54e-05
+ PS=1.72e-05 NRD=0.263889 NRS=0.458333
M4 OUT1 8 VDD VDD P L=8e-07 W=3.3e-06 AD=9.57e-12 AS=9.57e-12 PD=1.24e-05
+ PS=1.24e-05 NRD=0.333333 NRS=0.484848
M5 14 IN4 GROUND GROUND N L=8e-07 W=4.1e-06 AD=5.0225e-12 AS=1.189e-11
+ PD=6.55e-06 PS=1.4e-05 NRD=0.29878 NRS=0.390244
M6 15 IN3 14 GROUND N L=8e-07 W=4.1e-06 AD=7.6875e-12 AS=5.0225e-12 PD=7.85e-06
+ PS=6.55e-06 NRD=0.457317 NRS=0.29878
M7 16 IN2 15 GROUND N L=8e-07 W=4.1e-06 AD=3.075e-12 AS=7.6875e-12 PD=5.6e-06
+ PS=7.85e-06 NRD=0.182927 NRS=0.457317
M8 8 IN1 16 GROUND N L=8e-07 W=4.1e-06 AD=1.353e-11 AS=3.075e-12 PD=1.48e-05
+ PS=5.6e-06 NRD=0.439024 NRS=0.182927
M9 OUT1 8 GROUND GROUND N L=8e-07 W=2e-06 AD=7.76e-12 AS=7.76e-12 PD=1.14e-05
+ PS=1.14e-05 NRD=0.6 NRS=0.9
.ends

.subckt AND500 IN5 IN4 IN3 IN2 IN1 OUT1 GROUND VDD
M0 9 IN5 VDD VDD P L=8e-07 W=6e-06 AD=1.92e-11 AS=1.74e-11 PD=1.84e-05
+ PS=1.78e-05 NRD=0.211111 NRS=0.266667
M1 VDD IN4 9 VDD P L=8e-07 W=6e-06 AD=1.92e-11 AS=1.92e-11 PD=1.84e-05
+ PS=1.84e-05 NRD=0.211111 NRS=0.266667
M2 9 IN3 VDD VDD P L=8e-07 W=6e-06 AD=2.22e-11 AS=1.92e-11 PD=1.94e-05
+ PS=1.84e-05 NRD=0.211111 NRS=0.266667
M3 VDD IN2 9 VDD P L=8e-07 W=6e-06 AD=1.98e-11 AS=2.22e-11 PD=1.86e-05
+ PS=1.94e-05 NRD=0.222222 NRS=0.35
M4 9 IN1 VDD VDD P L=8e-07 W=6e-06 AD=1.74e-11 AS=1.98e-11 PD=1.78e-05
+ PS=1.86e-05 NRD=0.211111 NRS=0.266667
M5 VDD 9 OUT1 VDD P L=8e-07 W=3e-06 AD=8.7e-12 AS=8.7e-12 PD=1.18e-05
+ PS=1.18e-05 NRD=0.366667 NRS=0.533333
M6 16 IN5 GROUND GROUND N L=8e-07 W=5.3e-06 AD=6.36e-12 AS=1.537e-11 PD=7.7e-06
+ PS=1.64e-05 NRD=0.226415 NRS=0.301887
M7 17 IN4 16 GROUND N L=8e-07 W=5.3e-06 AD=8.215e-12 AS=6.36e-12 PD=8.4e-06
+ PS=7.7e-06 NRD=0.292453 NRS=0.226415
M8 18 IN3 17 GROUND N L=8e-07 W=5.3e-06 AD=1.961e-11 AS=8.215e-12 PD=1.27e-05
+ PS=8.4e-06 NRD=0.698113 NRS=0.292453
M9 19 IN2 18 GROUND N L=8e-07 W=5.3e-06 AD=3.445e-12 AS=1.961e-11 PD=6.6e-06
+ PS=1.27e-05 NRD=0.122642 NRS=0.698113
M10 9 IN1 19 GROUND N L=8e-07 W=5.3e-06 AD=2.31e-11 AS=3.445e-12 PD=2.11e-05
+ PS=6.6e-06 NRD=0.330189 NRS=0.122642
M11 OUT1 9 GROUND GROUND N L=8e-07 W=2e-06 AD=7.76e-12 AS=7.76e-12 PD=1.14e-05
+ PS=1.14e-05 NRD=0.6 NRS=0.9
.ends

.subckt AOI400 IN1 IN2 IN4 IN3 OUT1 VDD GROUND
M0 VDD IN1 7 VDD P L=8e-07 W=3.1e-06 AD=9.92e-12 AS=8.99e-12 PD=1.26e-05
+ PS=1.2e-05 NRD=0.354839 NRS=0.516129
M1 7 IN2 VDD VDD P L=8e-07 W=3.1e-06 AD=9.92e-12 AS=9.92e-12 PD=1.26e-05
+ PS=1.26e-05 NRD=0.354839 NRS=0.516129
M2 OUT1 IN4 7 VDD P L=8e-07 W=3.1e-06 AD=1.901e-11 AS=9.92e-12 PD=1.94e-05
+ PS=1.26e-05 NRD=0.580645 NRS=0.516129
M3 7 IN3 OUT1 VDD P L=8e-07 W=3.1e-06 AD=8.99e-12 AS=1.901e-11 PD=1.2e-05
+ PS=1.94e-05 NRD=0.516129 NRS=0.580645
M4 13 IN1 OUT1 GROUND N L=8e-07 W=2.9e-06 AD=1.45e-12 AS=8.99e-12 PD=3.9e-06
+ PS=1.2e-05 NRD=0.172414 NRS=0.62069
M5 GROUND IN2 13 GROUND N L=8e-07 W=2.9e-06 AD=3.545e-11 AS=1.45e-12 PD=2.53e-05
+ PS=3.9e-06 NRD=0.448276 NRS=0.172414
M6 14 IN4 GROUND GROUND N L=8e-07 W=2.9e-06 AD=1.595e-12 AS=3.545e-11 PD=4e-06
+ PS=2.53e-05 NRD=0.189655 NRS=0.65252
M7 OUT1 IN3 14 GROUND N L=8e-07 W=2.9e-06 AD=8.41e-12 AS=1.595e-12 PD=1.16e-05
+ PS=4e-06 NRD=0.551724 NRS=0.189655
.ends

.subckt DFCL11 C D CLR QB Q GROUND VDD
M0 VDD C 11 VDD P L=8e-07 W=3e-06 AD=9.6e-12 AS=8.7e-12 PD=1.24e-05 PS=1.18e-05
+ NRD=0.366667 NRS=0.533333
M1 12 11 VDD VDD P L=8e-07 W=3e-06 AD=8.7e-12 AS=9.6e-12 PD=1.18e-05 PS=1.24e-05
+ NRD=0.366667 NRS=0.533333
M2 3 12 D VDD P L=8e-07 W=3e-06 AD=1.05e-11 AS=8.7e-12 PD=1.3e-05 PS=1.18e-05
+ NRD=0.391667 NRS=0.533333
M3 4 11 3 VDD P L=8e-07 W=3e-06 AD=1.08e-11 AS=1.05e-11 PD=1.32e-05 PS=1.3e-05
+ NRD=0.408333 NRS=0.583333
M4 VDD 6 4 VDD P L=8e-07 W=3e-06 AD=8.7e-12 AS=1.08e-11 PD=1.18e-05 PS=1.32e-05
+ NRD=0.366667 NRS=0.583333
M5 VDD CLR 6 VDD P L=8e-07 W=3e-06 AD=9.6e-12 AS=8.7e-12 PD=1.24e-05 PS=1.18e-05
+ NRD=0.366667 NRS=0.533333
M6 6 3 VDD VDD P L=8e-07 W=3e-06 AD=1.08e-11 AS=9.6e-12 PD=1.32e-05 PS=1.24e-05
+ NRD=0.391667 NRS=0.533333
M7 7 11 6 VDD P L=8e-07 W=3e-06 AD=1.08e-11 AS=1.08e-11 PD=1.32e-05 PS=1.32e-05
+ NRD=0.391667 NRS=0.616667
M8 8 12 7 VDD P L=8e-07 W=3e-06 AD=1.05e-11 AS=1.08e-11 PD=1.3e-05 PS=1.32e-05
+ NRD=0.391667 NRS=0.616667
M9 VDD 13 8 VDD P L=8e-07 W=3e-06 AD=9.6e-12 AS=1.05e-11 PD=1.24e-05 PS=1.3e-05
+ NRD=0.366667 NRS=0.583333
M10 8 CLR VDD VDD P L=8e-07 W=3e-06 AD=8.7e-12 AS=9.6e-12 PD=1.18e-05
+ PS=1.24e-05 NRD=0.366667 NRS=0.533333
M11 13 7 VDD VDD P L=8e-07 W=3e-06 AD=8.7e-12 AS=8.7e-12 PD=1.18e-05 PS=1.18e-05
+ NRD=0.366667 NRS=0.533333
M12 VDD 13 QB VDD P L=8e-07 W=4.4e-06 AD=1.441e-11 AS=1.276e-11 PD=1.56e-05
+ PS=1.46e-05 NRD=0.25 NRS=0.363636
M13 Q QB VDD VDD P L=8e-07 W=4.6e-06 AD=1.334e-11 AS=1.441e-11 PD=1.5e-05
+ PS=1.56e-05 NRD=0.23913 NRS=0.347826
M14 GROUND C 11 GROUND N L=8e-07 W=2e-06 AD=8.24e-12 AS=7.5e-12 PD=1.2e-05
+ PS=1.12e-05 NRD=0.575 NRS=0.85
M15 12 11 GROUND GROUND N L=8e-07 W=2e-06 AD=7.5e-12 AS=8.24e-12 PD=1.12e-05
+ PS=1.2e-05 NRD=0.575 NRS=0.85
M16 3 11 D GROUND N L=8e-07 W=2e-06 AD=8.76e-12 AS=7.5e-12 PD=1.24e-05
+ PS=1.12e-05 NRD=0.6 NRS=0.85
M17 4 12 3 GROUND N L=8e-07 W=2e-06 AD=3.056e-11 AS=8.76e-12 PD=2.34e-05
+ PS=1.24e-05 NRD=0.9 NRS=0.9
M18 GROUND 6 4 GROUND N L=8e-07 W=2e-06 AD=2.236e-11 AS=3.056e-11 PD=2.42e-05
+ PS=2.34e-05 NRD=0.9 NRS=0.9
M19 29 CLR GROUND GROUND N L=8e-07 W=2e-06 AD=3.2e-12 AS=2.236e-11 PD=5.2e-06
+ PS=2.42e-05 NRD=0.8 NRS=0.9
M20 6 3 29 GROUND N L=8e-07 W=2e-06 AD=8.76e-12 AS=3.2e-12 PD=1.24e-05
+ PS=5.2e-06 NRD=0.9 NRS=0.8
M21 7 12 6 GROUND N L=8e-07 W=2e-06 AD=8.76e-12 AS=8.76e-12 PD=1.24e-05
+ PS=1.24e-05 NRD=0.6 NRS=0.9
M22 8 11 7 GROUND N L=8e-07 W=2e-06 AD=2.92e-11 AS=8.76e-12 PD=2.3e-05
+ PS=1.24e-05 NRD=0.9 NRS=0.9
M23 30 13 8 GROUND N L=8e-07 W=2e-06 AD=4.6e-12 AS=2.92e-11 PD=6.6e-06
+ PS=2.3e-05 NRD=1.15 NRS=0.9
M24 GROUND CLR 30 GROUND N L=8e-07 W=2e-06 AD=1.962e-11 AS=4.6e-12 PD=2.14e-05
+ PS=6.6e-06 NRD=0.9 NRS=1.15
M25 13 7 GROUND GROUND N L=8e-07 W=2e-06 AD=7.76e-12 AS=1.962e-11 PD=1.14e-05
+ PS=2.14e-05 NRD=0.9 NRS=0.9
M26 GROUND 13 QB GROUND N L=8e-07 W=2.4e-06 AD=9.16e-12 AS=7.96e-12 PD=1.24e-05
+ PS=1.14e-05 NRD=0.5 NRS=0.75
M27 Q QB GROUND GROUND N L=8e-07 W=2.4e-06 AD=7.96e-12 AS=9.16e-12 PD=1.14e-05
+ PS=1.24e-05 NRD=0.5 NRS=0.75
.ends

.subckt DFPR11 C D PRB QB Q GROUND VDD
M0 VDD C 11 VDD P L=8e-07 W=3.3e-06 AD=1.04e-11 AS=9.57e-12 PD=1.3e-05
+ PS=1.24e-05 NRD=0.333333 NRS=0.484848
M1 12 11 VDD VDD P L=8e-07 W=3.2e-06 AD=9.28e-12 AS=1.04e-11 PD=1.22e-05
+ PS=1.3e-05 NRD=0.34375 NRS=0.5
M2 3 12 D VDD P L=8e-07 W=4e-06 AD=1.35e-11 AS=1.16e-11 PD=1.5e-05 PS=1.38e-05
+ NRD=0.29375 NRS=0.4
M3 4 11 3 VDD P L=8e-07 W=3e-06 AD=1.111e-11 AS=1.35e-11 PD=1.34e-05 PS=1.5e-05
+ NRD=0.408333 NRS=0.583333
M4 VDD 6 4 VDD P L=8e-07 W=3.1e-06 AD=9.92e-12 AS=1.111e-11 PD=1.26e-05
+ PS=1.34e-05 NRD=0.354839 NRS=0.564516
M5 4 PRB VDD VDD P L=8e-07 W=3.1e-06 AD=8.99e-12 AS=9.92e-12 PD=1.2e-05
+ PS=1.26e-05 NRD=0.354839 NRS=0.516129
M6 6 3 VDD VDD P L=8e-07 W=3e-06 AD=1.08e-11 AS=8.7e-12 PD=1.32e-05 PS=1.18e-05
+ NRD=0.391667 NRS=0.533333
M7 7 11 6 VDD P L=8e-07 W=3e-06 AD=1.08e-11 AS=1.08e-11 PD=1.32e-05 PS=1.32e-05
+ NRD=0.391667 NRS=0.616667
M8 8 12 7 VDD P L=8e-07 W=3e-06 AD=1.05e-11 AS=1.08e-11 PD=1.3e-05 PS=1.32e-05
+ NRD=0.391667 NRS=0.616667
M9 VDD 13 8 VDD P L=8e-07 W=3e-06 AD=8.7e-12 AS=1.05e-11 PD=1.18e-05 PS=1.3e-05
+ NRD=0.366667 NRS=0.583333
M10 VDD PRB 13 VDD P L=8e-07 W=3.1e-06 AD=9.92e-12 AS=8.99e-12 PD=1.26e-05
+ PS=1.2e-05 NRD=0.354839 NRS=0.516129
M11 13 7 VDD VDD P L=8e-07 W=3.1e-06 AD=8.99e-12 AS=9.92e-12 PD=1.2e-05
+ PS=1.26e-05 NRD=0.354839 NRS=0.516129
M12 VDD 13 QB VDD P L=8e-07 W=4.4e-06 AD=1.434e-11 AS=1.276e-11 PD=1.54e-05
+ PS=1.46e-05 NRD=0.25 NRS=0.363636
M13 Q QB VDD VDD P L=8e-07 W=4.5e-06 AD=1.305e-11 AS=1.434e-11 PD=1.48e-05
+ PS=1.54e-05 NRD=0.244444 NRS=0.355556
M14 GROUND C 11 GROUND N L=8e-07 W=2e-06 AD=8.24e-12 AS=7.5e-12 PD=1.2e-05
+ PS=1.12e-05 NRD=0.575 NRS=0.85
M15 12 11 GROUND GROUND N L=8e-07 W=2e-06 AD=7.5e-12 AS=8.24e-12 PD=1.12e-05
+ PS=1.2e-05 NRD=0.575 NRS=0.85
M16 3 11 D GROUND N L=8e-07 W=2e-06 AD=8.76e-12 AS=7.5e-12 PD=1.24e-05
+ PS=1.12e-05 NRD=0.6 NRS=0.85
M17 4 12 3 GROUND N L=8e-07 W=2e-06 AD=3.076e-11 AS=8.76e-12 PD=2.34e-05
+ PS=1.24e-05 NRD=0.9 NRS=0.9
M18 29 6 4 GROUND N L=8e-07 W=2.4e-06 AD=2.88e-12 AS=3.076e-11 PD=4.8e-06
+ PS=2.34e-05 NRD=0.5 NRS=0.75
M19 GROUND PRB 29 GROUND N L=8e-07 W=2.4e-06 AD=2.794e-11 AS=2.88e-12
+ PD=2.76e-05 PS=4.8e-06 NRD=0.75 NRS=0.5
M20 6 3 GROUND GROUND N L=8e-07 W=2.2e-06 AD=8.86e-12 AS=2.794e-11 PD=1.24e-05
+ PS=2.76e-05 NRD=0.818182 NRS=0.818182
M21 7 12 6 GROUND N L=8e-07 W=2e-06 AD=8.76e-12 AS=8.86e-12 PD=1.24e-05
+ PS=1.24e-05 NRD=0.6 NRS=0.9
M22 8 11 7 GROUND N L=8e-07 W=2e-06 AD=2.77e-11 AS=8.76e-12 PD=2.24e-05
+ PS=1.24e-05 NRD=0.9 NRS=0.9
M23 GROUND 13 8 GROUND N L=8e-07 W=2e-06 AD=1.806e-11 AS=2.77e-11 PD=1.94e-05
+ PS=2.24e-05 NRD=0.9 NRS=0.9
M24 30 PRB GROUND GROUND N L=8e-07 W=2.4e-06 AD=4.8e-12 AS=1.806e-11 PD=6.4e-06
+ PS=1.94e-05 NRD=0.833333 NRS=0.75
M25 13 7 30 GROUND N L=8e-07 W=2.4e-06 AD=7.96e-12 AS=4.8e-12 PD=1.14e-05
+ PS=6.4e-06 NRD=0.75 NRS=0.833333
M26 GROUND 13 QB GROUND N L=8e-07 W=2.4e-06 AD=9.16e-12 AS=7.96e-12 PD=1.24e-05
+ PS=1.14e-05 NRD=0.5 NRS=0.75
M27 Q QB GROUND GROUND N L=8e-07 W=2.4e-06 AD=7.96e-12 AS=9.16e-12 PD=1.14e-05
+ PS=1.24e-05 NRD=0.5 NRS=0.75
.ends

.subckt BUFF00 IN1 OUT1 GROUND VDD
M0 VDD IN1 3 VDD P L=8e-07 W=3e-06 AD=1.119e-11 AS=9.3e-12 PD=1.36e-05
+ PS=1.22e-05 NRD=0.4 NRS=0.6
M1 OUT1 3 VDD VDD P L=8e-07 W=3.2e-06 AD=9.92e-12 AS=1.119e-11 PD=1.26e-05
+ PS=1.36e-05 NRD=0.375 NRS=0.5625
M2 GROUND IN1 3 GROUND N L=8e-07 W=2e-06 AD=8.76e-12 AS=7.76e-12 PD=1.24e-05
+ PS=1.14e-05 NRD=0.6 NRS=0.9
M3 OUT1 3 GROUND GROUND N L=8e-07 W=2e-06 AD=7.76e-12 AS=8.76e-12 PD=1.14e-05
+ PS=1.24e-05 NRD=0.6 NRS=0.9
.ends

.subckt FILLER1 GROUND VDD
.ends

.subckt FILLER5 GROUND VDD
.ends

.subckt FILLER3 GROUND VDD
.ends

.subckt FILLER6 GROUND VDD
.ends

.subckt FILLER2 GROUND VDD
.ends

.subckt FILLER4 GROUND VDD
.ends
