.subckt ASPAD00 GROUND PADIN VDD
*R0 PADIN 3 322.222
XR1 PADIN 3 RNW W=45u L=14.5u
D1 GROUND PADIN DNWELLPSUB  AREA=0.165684
D2 PADIN VDD DPDIFFNWELL  AREA=0.011189
D3 3 VDD DPDIFFNWELL  AREA=0.00322491
D4 GROUND 3 DNDIFFPSUB  AREA=0.0164366
.ends

.subckt BPT101 GROUND PAD CORE1 IO CORE VDD
M0 VDD 3 4 VDD P L=8e-07 W=5e-06 AD=6.918e-11 AS=1.45e-11 PD=5.26e-05
+ PS=1.58e-05 NRD=0.32 NRS=0.32
M1 CORE1 4 VDD VDD P L=8e-07 W=2.18e-05 AD=6.518e-11 AS=6.918e-11 PD=5.1e-05
+ PS=5.26e-05 NRD=0.0743119 NRS=0.0743119
M2 PAD 8 VDD VDD P L=8e-07 W=7e-05 AD=2.45e-10 AS=2.03e-10 PD=0.000147
+ PS=0.0001458 NRD=0.0228571 NRS=0.0228571
M3 VDD 8 PAD VDD P L=8e-07 W=7e-05 AD=2.03e-10 AS=2.45e-10 PD=0.0001458
+ PS=0.000147 NRD=0.0223963 NRS=0.0271429
M4 VDD 9 6 VDD P L=8e-07 W=3e-06 AD=9.6e-12 AS=8.7e-12 PD=1.24e-05 PS=1.18e-05
+ NRD=0.366667 NRS=0.533333
M5 VDD 10 8 VDD P L=8e-07 W=1.1e-05 AD=3.375e-11 AS=3.19e-11 PD=2.88e-05
+ PS=2.78e-05 NRD=0.127273 NRS=0.145455
M6 6 7 VDD VDD P L=8e-07 W=3e-06 AD=8.7e-12 AS=9.6e-12 PD=1.18e-05 PS=1.24e-05
+ NRD=0.366667 NRS=0.533333
M7 13 6 VDD VDD P L=8e-07 W=3.7e-06 AD=1.073e-11 AS=3.375e-11 PD=1.32e-05
+ PS=2.88e-05 NRD=0.297297 NRS=0.44226
M8 39 IO 10 VDD P L=8e-07 W=4.3e-06 AD=4.3e-12 AS=1.247e-11 PD=6.3e-06
+ PS=1.44e-05 NRD=0.232558 NRS=0.372093
M9 VDD 7 39 VDD P L=8e-07 W=4.3e-06 AD=1.247e-11 AS=4.3e-12 PD=1.44e-05
+ PS=6.3e-06 NRD=0.372093 NRS=0.232558
M10 VDD IO 9 VDD P L=8e-07 W=3e-06 AD=9.6e-12 AS=8.7e-12 PD=1.24e-05 PS=1.18e-05
+ NRD=0.366667 NRS=0.533333
M11 7 CORE VDD VDD P L=8e-07 W=3e-06 AD=8.7e-12 AS=9.6e-12 PD=1.18e-05
+ PS=1.24e-05 NRD=0.366667 NRS=0.533333
M12 GROUND 3 4 GROUND N L=8e-07 W=1.2e-05 AD=3.91e-11 AS=3.48e-11 PD=3.08e-05
+ PS=2.98e-05 NRD=0.119444 NRS=0.133333
M13 CORE1 4 GROUND GROUND N L=8e-07 W=8.6e-06 AD=2.69e-11 AS=3.91e-11
+ PD=2.46e-05 PS=3.08e-05 NRD=0.19186 NRS=0.188579
M14 GROUND 13 PAD GROUND N L=8e-07 W=4.4e-05 AD=1.296e-10 AS=1.2908e-10
+ PD=9.54e-05 PS=9.5e-05 NRD=0.0354978 NRS=0.0365909
M15 GROUND 6 13 GROUND N L=8e-07 W=2.3e-06 AD=1.465e-11 AS=7.91e-12 PD=1.6e-05
+ PS=1.14e-05 NRD=0.434783 NRS=0.782609
M16 GROUND IO 9 GROUND N L=8e-07 W=2e-06 AD=1.076e-11 AS=9e-12 PD=1.44e-05
+ PS=1.24e-05 NRD=0.725 NRS=1.05
M17 7 CORE GROUND GROUND N L=8e-07 W=2e-06 AD=8.76e-12 AS=1.076e-11 PD=1.24e-05
+ PS=1.44e-05 NRD=0.725 NRS=1.15
M18 40 7 6 GROUND N L=8e-07 W=2e-06 AD=1.55e-12 AS=7.76e-12 PD=3.55e-06
+ PS=1.14e-05 NRD=0.3875 NRS=0.9
M19 8 10 GROUND GROUND N L=8e-07 W=4.5e-06 AD=1.305e-11 AS=1.465e-11 PD=1.48e-05
+ PS=1.6e-05 NRD=0.244444 NRS=0.355556
M20 GROUND 9 40 GROUND N L=8e-07 W=2e-06 AD=7.76e-12 AS=1.55e-12 PD=1.14e-05
+ PS=3.55e-06 NRD=0.9 NRS=0.3875
M21 GROUND 7 10 GROUND N L=8e-07 W=2e-06 AD=8.76e-12 AS=7.76e-12 PD=1.24e-05
+ PS=1.14e-05 NRD=0.6 NRS=0.9
M22 10 IO GROUND GROUND N L=8e-07 W=2e-06 AD=7.76e-12 AS=8.76e-12 PD=1.14e-05
+ PS=1.24e-05 NRD=0.6 NRS=0.9
*R23 PAD 3 322.222
XR1 PAD 3 RNW W=45u L=14.5u
D24 GROUND PAD DNWELLPSUB  AREA=0.166945
D25 PAD VDD DPDIFFNWELL  AREA=0.011189
D26 3 VDD DPDIFFNWELL  AREA=0.00322491
D27 GROUND 3 DNDIFFPSUB  AREA=0.0164366
.ends

.subckt BPT102 GROUND PAD CORE1 IO CORE VDD
M0 VDD 3 4 VDD P L=8e-07 W=5e-06 AD=6.918e-11 AS=1.45e-11 PD=5.26e-05
+ PS=1.58e-05 NRD=0.32 NRS=0.32
M1 CORE1 4 VDD VDD P L=8e-07 W=2.18e-05 AD=6.518e-11 AS=6.918e-11 PD=5.1e-05
+ PS=5.26e-05 NRD=0.0743119 NRS=0.0743119
M2 PAD 8 VDD VDD P L=8e-07 W=6.75e-05 AD=2.3625e-10 AS=1.9651e-10 PD=0.000142
+ PS=0.0001414 NRD=0.0227778 NRS=0.0238025
M3 VDD 8 PAD VDD P L=8e-07 W=6.75e-05 AD=2.3625e-10 AS=2.3625e-10 PD=0.000142
+ PS=0.000142 NRD=0.0232099 NRS=0.0281481
M4 PAD 8 VDD VDD P L=8e-07 W=6.75e-05 AD=2.3625e-10 AS=2.3625e-10 PD=0.000142
+ PS=0.000142 NRD=0.0227778 NRS=0.0281481
M5 VDD 8 PAD VDD P L=8e-07 W=6.75e-05 AD=2.0025e-10 AS=2.3625e-10 PD=0.0001418
+ PS=0.000142 NRD=0.0233214 NRS=0.0281481
M6 VDD 9 6 VDD P L=8e-07 W=5.1e-06 AD=1.632e-11 AS=1.479e-11 PD=1.66e-05
+ PS=1.6e-05 NRD=0.248366 NRS=0.313725
M7 VDD 10 8 VDD P L=8e-07 W=1.8e-05 AD=5.47e-11 AS=5.22e-11 PD=4.28e-05
+ PS=4.18e-05 NRD=0.0819444 NRS=0.0888889
M8 6 7 VDD VDD P L=8e-07 W=5.1e-06 AD=1.479e-11 AS=1.632e-11 PD=1.6e-05
+ PS=1.66e-05 NRD=0.248366 NRS=0.313725
M9 13 6 VDD VDD P L=8e-07 W=5e-06 AD=1.45e-11 AS=5.47e-11 PD=1.58e-05
+ PS=4.28e-05 NRD=0.32 NRS=0.282857
M10 41 IO 10 VDD P L=8e-07 W=8.5e-06 AD=8.5e-12 AS=2.465e-11 PD=1.05e-05
+ PS=2.28e-05 NRD=0.117647 NRS=0.188235
M11 VDD 7 41 VDD P L=8e-07 W=8.5e-06 AD=2.465e-11 AS=8.5e-12 PD=2.28e-05
+ PS=1.05e-05 NRD=0.188235 NRS=0.117647
M12 VDD IO 9 VDD P L=8e-07 W=3e-06 AD=9.6e-12 AS=8.7e-12 PD=1.24e-05 PS=1.18e-05
+ NRD=0.366667 NRS=0.533333
M13 7 CORE VDD VDD P L=8e-07 W=3e-06 AD=8.7e-12 AS=9.6e-12 PD=1.18e-05
+ PS=1.24e-05 NRD=0.366667 NRS=0.533333
M14 GROUND 3 4 GROUND N L=8e-07 W=1.2e-05 AD=3.91e-11 AS=3.48e-11 PD=3.08e-05
+ PS=2.98e-05 NRD=0.119444 NRS=0.133333
M15 CORE1 4 GROUND GROUND N L=8e-07 W=8.6e-06 AD=2.69e-11 AS=3.91e-11
+ PD=2.46e-05 PS=3.08e-05 NRD=0.19186 NRS=0.188579
M16 GROUND 13 PAD GROUND N L=8e-07 W=4.25e-05 AD=3.57e-10 AS=1.2325e-10
+ PD=0.0001018 PS=9.08e-05 NRD=0.0356863 NRS=0.0376471
M17 PAD 13 GROUND GROUND N L=8e-07 W=4.25e-05 AD=1.2325e-10 AS=3.57e-10
+ PD=9.08e-05 PS=0.0001018 NRD=0.0376471 NRS=0.0376471
M18 GROUND 6 13 GROUND N L=8e-07 W=3e-06 AD=1.98e-11 AS=8.7e-12 PD=1.92e-05
+ PS=1.18e-05 NRD=0.416667 NRS=0.533333
M19 GROUND IO 9 GROUND N L=8e-07 W=2e-06 AD=1.076e-11 AS=9e-12 PD=1.44e-05
+ PS=1.24e-05 NRD=0.725 NRS=1.05
M20 7 CORE GROUND GROUND N L=8e-07 W=2e-06 AD=8.76e-12 AS=1.076e-11 PD=1.24e-05
+ PS=1.44e-05 NRD=0.725 NRS=1.15
M21 42 7 6 GROUND N L=8e-07 W=3.4e-06 AD=2.635e-12 AS=1.054e-11 PD=4.95e-06
+ PS=1.3e-05 NRD=0.227941 NRS=0.529412
M22 8 10 GROUND GROUND N L=8e-07 W=6.1e-06 AD=1.769e-11 AS=1.98e-11 PD=1.8e-05
+ PS=1.92e-05 NRD=0.20765 NRS=0.262295
M23 GROUND 9 42 GROUND N L=8e-07 W=3.4e-06 AD=1.054e-11 AS=2.635e-12 PD=1.3e-05
+ PS=4.95e-06 NRD=0.529412 NRS=0.227941
M24 GROUND 7 10 GROUND N L=8e-07 W=2.8e-06 AD=8.96e-12 AS=8.12e-12 PD=1.2e-05
+ PS=1.14e-05 NRD=0.392857 NRS=0.571429
M25 10 IO GROUND GROUND N L=8e-07 W=2.8e-06 AD=8.12e-12 AS=8.96e-12 PD=1.14e-05
+ PS=1.2e-05 NRD=0.392857 NRS=0.571429
*R26 PAD 3 322.222
XR1 PAD 3 RNW W=45u L=14.5u
D27 GROUND PAD DNWELLPSUB  AREA=0.166945
D28 PAD VDD DPDIFFNWELL  AREA=0.011189
D29 3 VDD DPDIFFNWELL  AREA=0.00322491
D30 GROUND 3 DNDIFFPSUB  AREA=0.0164366
.ends

.subckt BPT103 GROUND PAD CORE1 IO CORE VDD
M0 VDD 3 4 VDD P L=8e-07 W=5e-06 AD=6.918e-11 AS=1.45e-11 PD=5.26e-05
+ PS=1.58e-05 NRD=0.32 NRS=0.32
M1 CORE1 4 VDD VDD P L=8e-07 W=2.18e-05 AD=6.518e-11 AS=6.918e-11 PD=5.1e-05
+ PS=5.26e-05 NRD=0.0743119 NRS=0.0743119
M2 PAD 8 VDD VDD P L=8e-07 W=7e-05 AD=2.45e-10 AS=2.03e-10 PD=0.000147
+ PS=0.0001458 NRD=0.0228571 NRS=0.0228571
M3 VDD 8 PAD VDD P L=8e-07 W=7e-05 AD=2.45e-10 AS=2.45e-10 PD=0.000147
+ PS=0.000147 NRD=0.0224107 NRS=0.0271429
M4 PAD 8 VDD VDD P L=8e-07 W=7e-05 AD=2.3825e-10 AS=2.45e-10 PD=0.000147
+ PS=0.000147 NRD=0.0228571 NRS=0.0271429
M5 VDD 8 PAD VDD P L=8e-07 W=5.65e-05 AD=3.051e-10 AS=2.3825e-10 PD=0.0001238
+ PS=0.000147 NRD=0.0276106 NRS=0.0334031
M6 PAD 8 VDD VDD P L=8e-07 W=5.65e-05 AD=2.3825e-10 AS=3.051e-10 PD=0.000147
+ PS=0.0001238 NRD=0.0315044 NRS=0.0283186
M7 VDD 8 PAD VDD P L=8e-07 W=7e-05 AD=2.45e-10 AS=2.3825e-10 PD=0.000147
+ PS=0.000147 NRD=0.0265625 NRS=0.0228571
M8 PAD 8 VDD VDD P L=8e-07 W=7e-05 AD=2.45e-10 AS=2.45e-10 PD=0.000147
+ PS=0.000147 NRD=0.0271429 NRS=0.0228571
M9 VDD 8 PAD VDD P L=8e-07 W=7e-05 AD=2.03e-10 AS=2.45e-10 PD=0.0001458
+ PS=0.000147 NRD=0.0224107 NRS=0.0228571
M10 VDD 9 6 VDD P L=8e-07 W=3e-06 AD=9.6e-12 AS=8.7e-12 PD=1.24e-05 PS=1.18e-05
+ NRD=0.366667 NRS=0.533333
M11 VDD 10 8 VDD P L=8e-07 W=4.73e-05 AD=1.4387e-10 AS=1.3717e-10 PD=0.0001014
+ PS=0.0001004 NRD=0.0327696 NRS=0.0338266
M12 6 7 VDD VDD P L=8e-07 W=3e-06 AD=8.7e-12 AS=9.6e-12 PD=1.18e-05 PS=1.24e-05
+ NRD=0.366667 NRS=0.533333
M13 13 6 VDD VDD P L=8e-07 W=1.34e-05 AD=3.986e-11 AS=1.4387e-10 PD=3.34e-05
+ PS=0.0001014 NRD=0.110874 NRS=0.135685
M14 42 IO 10 VDD P L=8e-07 W=1.22e-05 AD=1.22e-11 AS=3.538e-11 PD=1.42e-05
+ PS=3.02e-05 NRD=0.0819672 NRS=0.131148
M15 VDD 7 42 VDD P L=8e-07 W=1.22e-05 AD=3.538e-11 AS=1.22e-11 PD=3.02e-05
+ PS=1.42e-05 NRD=0.131148 NRS=0.0819672
M16 VDD IO 9 VDD P L=8e-07 W=3e-06 AD=9.6e-12 AS=8.7e-12 PD=1.24e-05 PS=1.18e-05
+ NRD=0.366667 NRS=0.533333
M17 7 CORE VDD VDD P L=8e-07 W=3e-06 AD=8.7e-12 AS=9.6e-12 PD=1.18e-05
+ PS=1.24e-05 NRD=0.366667 NRS=0.533333
M18 GROUND 3 4 GROUND N L=8e-07 W=1.2e-05 AD=3.91e-11 AS=3.48e-11 PD=3.08e-05
+ PS=2.98e-05 NRD=0.119444 NRS=0.133333
M19 CORE1 4 GROUND GROUND N L=8e-07 W=8.6e-06 AD=2.69e-11 AS=3.91e-11
+ PD=2.46e-05 PS=3.08e-05 NRD=0.19186 NRS=0.188579
M20 GROUND 13 PAD GROUND N L=8e-07 W=7e-05 AD=5.88e-10 AS=2.03e-10 PD=0.0001568
+ PS=0.0001458 NRD=0.0220635 NRS=0.0228571
M21 PAD 13 GROUND GROUND N L=8e-07 W=7e-05 AD=2.2185e-10 AS=5.88e-10
+ PD=0.0001471 PS=0.0001568 NRD=0.0219643 NRS=0.0228571
M22 GROUND 13 PAD GROUND N L=8e-07 W=2.9e-05 AD=8.7e-11 AS=2.2185e-10 PD=6.4e-05
+ PS=0.0001471 NRD=0.0586207 NRS=0.0623054
M23 GROUND 6 13 GROUND N L=8e-07 W=5e-06 AD=6.326e-11 AS=1.45e-11 PD=4.76e-05
+ PS=1.58e-05 NRD=0.293333 NRS=0.32
M24 GROUND IO 9 GROUND N L=8e-07 W=2e-06 AD=1.076e-11 AS=9e-12 PD=1.44e-05
+ PS=1.24e-05 NRD=0.725 NRS=1.05
M25 7 CORE GROUND GROUND N L=8e-07 W=2e-06 AD=8.76e-12 AS=1.076e-11 PD=1.24e-05
+ PS=1.44e-05 NRD=0.725 NRS=1.15
M26 43 7 6 GROUND N L=8e-07 W=2e-06 AD=1.55e-12 AS=7.76e-12 PD=3.55e-06
+ PS=1.14e-05 NRD=0.3875 NRS=0.9
M27 8 10 GROUND GROUND N L=8e-07 W=2e-05 AD=5.9e-11 AS=6.326e-11 PD=4.66e-05
+ PS=4.76e-05 NRD=0.076 NRS=0.0811111
M28 GROUND 9 43 GROUND N L=8e-07 W=2e-06 AD=7.76e-12 AS=1.55e-12 PD=1.14e-05
+ PS=3.55e-06 NRD=0.9 NRS=0.3875
M29 GROUND 7 10 GROUND N L=8e-07 W=3.2e-06 AD=1.024e-11 AS=9.28e-12 PD=1.28e-05
+ PS=1.22e-05 NRD=0.34375 NRS=0.5
M30 10 IO GROUND GROUND N L=8e-07 W=3.2e-06 AD=9.28e-12 AS=1.024e-11 PD=1.22e-05
+ PS=1.28e-05 NRD=0.34375 NRS=0.5
*R31 PAD 3 322.222
XR1 PAD 3 RNW W=45u L=14.5u
D32 GROUND PAD DNWELLPSUB  AREA=0.166945
D33 PAD VDD DPDIFFNWELL  AREA=0.011189
D34 3 VDD DPDIFFNWELL  AREA=0.00322491
D35 GROUND 3 DNDIFFPSUB  AREA=0.0164366
.ends

.subckt BPT201 GROUND PAD CORE1 IO CORE VDD
M0 VDD 3 4 VDD P L=8e-07 W=4.6e-06 AD=8.142e-11 AS=1.334e-11 PD=6.14e-05
+ PS=1.5e-05 NRD=0.347826 NRS=0.347826
M1 CORE1 4 VDD VDD P L=8e-07 W=2.58e-05 AD=7.774e-11 AS=8.142e-11 PD=5.98e-05
+ PS=6.14e-05 NRD=0.0610465 NRS=0.0605288
M2 PAD 8 VDD VDD P L=8e-07 W=7e-05 AD=2.45e-10 AS=2.03e-10 PD=0.000147
+ PS=0.0001458 NRD=0.0228571 NRS=0.0228571
M3 VDD 8 PAD VDD P L=8e-07 W=7e-05 AD=2.1e-10 AS=2.45e-10 PD=0.000146
+ PS=0.000147 NRD=0.0224107 NRS=0.0271429
M4 3 GROUND VDD VDD P L=3e-06 W=2e-06 AD=7.76e-12 AS=7.76e-12 PD=1.14e-05
+ PS=1.14e-05 NRD=0.6 NRS=0.9
M5 VDD 9 6 VDD P L=8e-07 W=3e-06 AD=9.6e-12 AS=8.7e-12 PD=1.24e-05 PS=1.18e-05
+ NRD=0.366667 NRS=0.533333
M6 VDD 10 8 VDD P L=8e-07 W=1.1e-05 AD=3.375e-11 AS=3.19e-11 PD=2.88e-05
+ PS=2.78e-05 NRD=0.127273 NRS=0.145455
M7 6 7 VDD VDD P L=8e-07 W=3e-06 AD=8.7e-12 AS=9.6e-12 PD=1.18e-05 PS=1.24e-05
+ NRD=0.366667 NRS=0.533333
M8 13 6 VDD VDD P L=8e-07 W=3.7e-06 AD=1.073e-11 AS=3.375e-11 PD=1.32e-05
+ PS=2.88e-05 NRD=0.297297 NRS=0.44226
M9 40 IO 10 VDD P L=8e-07 W=4.3e-06 AD=4.3e-12 AS=1.247e-11 PD=6.3e-06
+ PS=1.44e-05 NRD=0.232558 NRS=0.372093
M10 VDD 7 40 VDD P L=8e-07 W=4.3e-06 AD=1.247e-11 AS=4.3e-12 PD=1.44e-05
+ PS=6.3e-06 NRD=0.372093 NRS=0.232558
M11 VDD IO 9 VDD P L=8e-07 W=3e-06 AD=9.6e-12 AS=8.7e-12 PD=1.24e-05 PS=1.18e-05
+ NRD=0.366667 NRS=0.533333
M12 7 CORE VDD VDD P L=8e-07 W=3e-06 AD=8.7e-12 AS=9.6e-12 PD=1.18e-05
+ PS=1.24e-05 NRD=0.366667 NRS=0.533333
M13 GROUND 3 4 GROUND N L=8e-07 W=9.9e-06 AD=3.346e-11 AS=2.871e-11 PD=2.66e-05
+ PS=2.56e-05 NRD=0.141414 NRS=0.161616
M14 CORE1 4 GROUND GROUND N L=8e-07 W=9.5e-06 AD=2.755e-11 AS=3.346e-11
+ PD=2.48e-05 PS=2.66e-05 NRD=0.147368 NRS=0.189474
M15 GROUND 13 PAD GROUND N L=8e-07 W=4.4e-05 AD=1.296e-10 AS=1.2908e-10
+ PD=9.54e-05 PS=9.5e-05 NRD=0.0354978 NRS=0.0365909
M16 GROUND 6 13 GROUND N L=8e-07 W=2.3e-06 AD=1.465e-11 AS=7.91e-12 PD=1.6e-05
+ PS=1.14e-05 NRD=0.434783 NRS=0.782609
M17 GROUND IO 9 GROUND N L=8e-07 W=2e-06 AD=1.076e-11 AS=9e-12 PD=1.44e-05
+ PS=1.24e-05 NRD=0.725 NRS=1.05
M18 7 CORE GROUND GROUND N L=8e-07 W=2e-06 AD=8.76e-12 AS=1.076e-11 PD=1.24e-05
+ PS=1.44e-05 NRD=0.725 NRS=1.15
M19 41 7 6 GROUND N L=8e-07 W=2e-06 AD=1.55e-12 AS=7.76e-12 PD=3.55e-06
+ PS=1.14e-05 NRD=0.3875 NRS=0.9
M20 8 10 GROUND GROUND N L=8e-07 W=4.5e-06 AD=1.305e-11 AS=1.465e-11 PD=1.48e-05
+ PS=1.6e-05 NRD=0.244444 NRS=0.355556
M21 GROUND 9 41 GROUND N L=8e-07 W=2e-06 AD=7.76e-12 AS=1.55e-12 PD=1.14e-05
+ PS=3.55e-06 NRD=0.9 NRS=0.3875
M22 GROUND 7 10 GROUND N L=8e-07 W=2e-06 AD=8.76e-12 AS=7.76e-12 PD=1.24e-05
+ PS=1.14e-05 NRD=0.6 NRS=0.9
M23 10 IO GROUND GROUND N L=8e-07 W=2e-06 AD=7.76e-12 AS=8.76e-12 PD=1.14e-05
+ PS=1.24e-05 NRD=0.6 NRS=0.9
*R24 PAD 3 322.222
XR1 PAD 3 RNW W=45u L=14.5u
D25 GROUND PAD DNWELLPSUB  AREA=0.166945
D26 PAD VDD DPDIFFNWELL  AREA=0.011189
D27 3 VDD DPDIFFNWELL  AREA=0.00322491
D28 GROUND 3 DNDIFFPSUB  AREA=0.0164366
.ends

.subckt BPT202 GROUND PAD CORE1 IO CORE VDD
M0 VDD 3 4 VDD P L=8e-07 W=4.6e-06 AD=8.142e-11 AS=1.334e-11 PD=6.14e-05
+ PS=1.5e-05 NRD=0.347826 NRS=0.347826
M1 CORE1 4 VDD VDD P L=8e-07 W=2.58e-05 AD=7.782e-11 AS=8.142e-11 PD=5.98e-05
+ PS=6.14e-05 NRD=0.0610465 NRS=0.0605288
M2 PAD 8 VDD VDD P L=8e-07 W=6.75e-05 AD=2.3625e-10 AS=1.9651e-10 PD=0.000142
+ PS=0.0001414 NRD=0.022924 NRS=0.0238025
M3 VDD 8 PAD VDD P L=8e-07 W=6.75e-05 AD=2.3625e-10 AS=2.3625e-10 PD=0.000142
+ PS=0.000142 NRD=0.0232099 NRS=0.0281481
M4 PAD 8 VDD VDD P L=8e-07 W=6.75e-05 AD=2.3625e-10 AS=2.3625e-10 PD=0.000142
+ PS=0.000142 NRD=0.022924 NRS=0.0281481
M5 VDD 8 PAD VDD P L=8e-07 W=6.75e-05 AD=2.0025e-10 AS=2.3625e-10 PD=0.0001418
+ PS=0.000142 NRD=0.0233214 NRS=0.0281481
M6 3 GROUND VDD VDD P L=3e-06 W=2e-06 AD=7.76e-12 AS=7.76e-12 PD=1.14e-05
+ PS=1.14e-05 NRD=0.6 NRS=0.9
M7 VDD 9 6 VDD P L=8e-07 W=5.1e-06 AD=1.632e-11 AS=1.479e-11 PD=1.66e-05
+ PS=1.6e-05 NRD=0.248366 NRS=0.313725
M8 VDD 10 8 VDD P L=8e-07 W=1.8e-05 AD=5.47e-11 AS=5.22e-11 PD=4.28e-05
+ PS=4.18e-05 NRD=0.0819444 NRS=0.0888889
M9 6 7 VDD VDD P L=8e-07 W=5.1e-06 AD=1.479e-11 AS=1.632e-11 PD=1.6e-05
+ PS=1.66e-05 NRD=0.248366 NRS=0.313725
M10 13 6 VDD VDD P L=8e-07 W=5e-06 AD=1.45e-11 AS=5.47e-11 PD=1.58e-05
+ PS=4.28e-05 NRD=0.32 NRS=0.282857
M11 43 IO 10 VDD P L=8e-07 W=8.5e-06 AD=8.5e-12 AS=2.465e-11 PD=1.05e-05
+ PS=2.28e-05 NRD=0.117647 NRS=0.188235
M12 VDD 7 43 VDD P L=8e-07 W=8.5e-06 AD=2.465e-11 AS=8.5e-12 PD=2.28e-05
+ PS=1.05e-05 NRD=0.188235 NRS=0.117647
M13 VDD IO 9 VDD P L=8e-07 W=3e-06 AD=9.6e-12 AS=8.7e-12 PD=1.24e-05 PS=1.18e-05
+ NRD=0.366667 NRS=0.533333
M14 7 CORE VDD VDD P L=8e-07 W=3e-06 AD=8.7e-12 AS=9.6e-12 PD=1.18e-05
+ PS=1.24e-05 NRD=0.366667 NRS=0.533333
M15 GROUND 3 4 GROUND N L=8e-07 W=9.9e-06 AD=3.346e-11 AS=2.871e-11 PD=2.66e-05
+ PS=2.56e-05 NRD=0.141414 NRS=0.161616
M16 CORE1 4 GROUND GROUND N L=8e-07 W=9.5e-06 AD=2.755e-11 AS=3.346e-11
+ PD=2.48e-05 PS=2.66e-05 NRD=0.147368 NRS=0.189474
M17 GROUND 13 PAD GROUND N L=8e-07 W=4.25e-05 AD=3.57e-10 AS=1.2325e-10
+ PD=0.0001018 PS=9.08e-05 NRD=0.0356863 NRS=0.0376471
M18 PAD 13 GROUND GROUND N L=8e-07 W=4.25e-05 AD=1.2325e-10 AS=3.57e-10
+ PD=9.08e-05 PS=0.0001018 NRD=0.0376471 NRS=0.0376471
M19 GROUND 6 13 GROUND N L=8e-07 W=3e-06 AD=1.98e-11 AS=9e-12 PD=1.92e-05
+ PS=1.2e-05 NRD=0.416667 NRS=0.533333
M20 GROUND IO 9 GROUND N L=8e-07 W=2e-06 AD=1.076e-11 AS=9e-12 PD=1.44e-05
+ PS=1.24e-05 NRD=0.725 NRS=1.05
M21 7 CORE GROUND GROUND N L=8e-07 W=2e-06 AD=8.76e-12 AS=1.076e-11 PD=1.24e-05
+ PS=1.44e-05 NRD=0.725 NRS=1.15
M22 44 7 6 GROUND N L=8e-07 W=3.4e-06 AD=2.635e-12 AS=1.054e-11 PD=4.95e-06
+ PS=1.3e-05 NRD=0.227941 NRS=0.529412
M23 8 10 GROUND GROUND N L=8e-07 W=6.1e-06 AD=1.769e-11 AS=1.98e-11 PD=1.8e-05
+ PS=1.92e-05 NRD=0.20765 NRS=0.262295
M24 GROUND 9 44 GROUND N L=8e-07 W=3.4e-06 AD=1.054e-11 AS=2.635e-12 PD=1.3e-05
+ PS=4.95e-06 NRD=0.529412 NRS=0.227941
M25 GROUND 7 10 GROUND N L=8e-07 W=2.8e-06 AD=8.96e-12 AS=8.12e-12 PD=1.2e-05
+ PS=1.14e-05 NRD=0.392857 NRS=0.571429
M26 10 IO GROUND GROUND N L=8e-07 W=2.8e-06 AD=8.12e-12 AS=8.96e-12 PD=1.14e-05
+ PS=1.2e-05 NRD=0.392857 NRS=0.571429
*R27 PAD 3 322.222
XR1 PAD 3 RNW W=45u L=14.5u
D28 GROUND PAD DNWELLPSUB  AREA=0.166945
D29 PAD VDD DPDIFFNWELL  AREA=0.011189
D30 3 VDD DPDIFFNWELL  AREA=0.00322491
D31 GROUND 3 DNDIFFPSUB  AREA=0.0164366
.ends

.subckt BPT301 GROUND PAD CORE1 VDD IO CORE
M0 VDD 3 4 VDD P L=8e-07 W=5e-06 AD=6.461e-11 AS=1.45e-11 PD=4.92e-05
+ PS=1.58e-05 NRD=0.32 NRS=0.32
M1 CORE1 4 VDD VDD P L=8e-07 W=2.09e-05 AD=6.061e-11 AS=6.461e-11 PD=4.76e-05
+ PS=4.92e-05 NRD=0.0717703 NRS=0.076555
M2 PAD 9 VDD VDD P L=8e-07 W=7e-05 AD=2.45e-10 AS=2.03e-10 PD=0.000147
+ PS=0.0001458 NRD=0.0228571 NRS=0.0228571
M3 VDD 9 PAD VDD P L=8e-07 W=7e-05 AD=2.1e-10 AS=2.45e-10 PD=0.000146
+ PS=0.000147 NRD=0.0223963 NRS=0.0271429
M4 VDD 10 7 VDD P L=8e-07 W=3e-06 AD=9.6e-12 AS=8.7e-12 PD=1.24e-05 PS=1.18e-05
+ NRD=0.366667 NRS=0.533333
M5 VDD 11 9 VDD P L=8e-07 W=1.1e-05 AD=3.375e-11 AS=3.19e-11 PD=2.88e-05
+ PS=2.78e-05 NRD=0.127273 NRS=0.145455
M6 7 8 VDD VDD P L=8e-07 W=3e-06 AD=8.7e-12 AS=9.6e-12 PD=1.18e-05 PS=1.24e-05
+ NRD=0.366667 NRS=0.533333
M7 14 7 VDD VDD P L=8e-07 W=3.7e-06 AD=1.073e-11 AS=3.375e-11 PD=1.32e-05
+ PS=2.88e-05 NRD=0.297297 NRS=0.44226
M8 43 IO 11 VDD P L=8e-07 W=4.3e-06 AD=4.3e-12 AS=1.247e-11 PD=6.3e-06
+ PS=1.44e-05 NRD=0.232558 NRS=0.372093
M9 VDD 8 43 VDD P L=8e-07 W=4.3e-06 AD=1.247e-11 AS=4.3e-12 PD=1.44e-05
+ PS=6.3e-06 NRD=0.372093 NRS=0.232558
M10 VDD IO 10 VDD P L=8e-07 W=3e-06 AD=9.6e-12 AS=8.7e-12 PD=1.24e-05
+ PS=1.18e-05 NRD=0.366667 NRS=0.533333
M11 8 CORE VDD VDD P L=8e-07 W=3e-06 AD=8.7e-12 AS=9.6e-12 PD=1.18e-05
+ PS=1.24e-05 NRD=0.366667 NRS=0.533333
M12 GROUND 3 4 GROUND N L=8e-07 W=1.52e-05 AD=5.029e-11 AS=4.604e-11 PD=3.88e-05
+ PS=3.78e-05 NRD=0.0986842 NRS=0.107143
M13 CORE1 4 GROUND GROUND N L=8e-07 W=8.5e-06 AD=2.685e-11 AS=5.029e-11
+ PD=2.46e-05 PS=3.88e-05 NRD=0.179412 NRS=0.185128
M14 GROUND 14 PAD GROUND N L=8e-07 W=4.4e-05 AD=1.296e-10 AS=1.2908e-10
+ PD=9.54e-05 PS=9.5e-05 NRD=0.0354978 NRS=0.0365909
M15 GROUND VDD 3 GROUND N L=1e-05 W=2e-06 AD=7.76e-12 AS=7.86e-12 PD=1.14e-05
+ PS=1.15e-05 NRD=0.6 NRS=0.925
M16 GROUND 7 14 GROUND N L=8e-07 W=2.3e-06 AD=1.465e-11 AS=7.91e-12 PD=1.6e-05
+ PS=1.14e-05 NRD=0.434783 NRS=0.782609
M17 GROUND IO 10 GROUND N L=8e-07 W=2e-06 AD=1.076e-11 AS=9e-12 PD=1.44e-05
+ PS=1.24e-05 NRD=0.725 NRS=1.05
M18 8 CORE GROUND GROUND N L=8e-07 W=2e-06 AD=8.76e-12 AS=1.076e-11 PD=1.24e-05
+ PS=1.44e-05 NRD=0.725 NRS=1.15
M19 44 8 7 GROUND N L=8e-07 W=2e-06 AD=1.55e-12 AS=7.76e-12 PD=3.55e-06
+ PS=1.14e-05 NRD=0.3875 NRS=0.9
M20 9 11 GROUND GROUND N L=8e-07 W=4.5e-06 AD=1.305e-11 AS=1.465e-11 PD=1.48e-05
+ PS=1.6e-05 NRD=0.244444 NRS=0.355556
M21 GROUND 10 44 GROUND N L=8e-07 W=2e-06 AD=7.76e-12 AS=1.55e-12 PD=1.14e-05
+ PS=3.55e-06 NRD=0.9 NRS=0.3875
M22 GROUND 8 11 GROUND N L=8e-07 W=2e-06 AD=8.76e-12 AS=7.76e-12 PD=1.24e-05
+ PS=1.14e-05 NRD=0.6 NRS=0.9
M23 11 IO GROUND GROUND N L=8e-07 W=2e-06 AD=7.76e-12 AS=8.76e-12 PD=1.14e-05
+ PS=1.24e-05 NRD=0.6 NRS=0.9
*R24 PAD 3 322.222
XR1 PAD 3 RNW W=45u L=14.5u
D25 GROUND PAD DNWELLPSUB  AREA=0.166945
D26 PAD VDD DPDIFFNWELL  AREA=0.011189
D27 3 VDD DPDIFFNWELL  AREA=0.00322491
D28 GROUND 3 DNDIFFPSUB  AREA=0.0164366
.ends

.subckt BPT302 GROUND PAD CORE1 VDD IO CORE
M0 VDD 3 4 VDD P L=8e-07 W=5e-06 AD=6.461e-11 AS=1.45e-11 PD=4.92e-05
+ PS=1.58e-05 NRD=0.32 NRS=0.32
M1 CORE1 4 VDD VDD P L=8e-07 W=2.09e-05 AD=6.061e-11 AS=6.461e-11 PD=4.76e-05
+ PS=4.92e-05 NRD=0.0717703 NRS=0.076555
M2 PAD 9 VDD VDD P L=8e-07 W=6.75e-05 AD=2.3625e-10 AS=1.9651e-10 PD=0.000142
+ PS=0.0001414 NRD=0.0227778 NRS=0.0238025
M3 VDD 9 PAD VDD P L=8e-07 W=6.75e-05 AD=2.3625e-10 AS=2.3625e-10 PD=0.000142
+ PS=0.000142 NRD=0.0232099 NRS=0.0281481
M4 PAD 9 VDD VDD P L=8e-07 W=6.75e-05 AD=2.3625e-10 AS=2.3625e-10 PD=0.000142
+ PS=0.000142 NRD=0.0227778 NRS=0.0281481
M5 VDD 9 PAD VDD P L=8e-07 W=6.75e-05 AD=2.0025e-10 AS=2.3625e-10 PD=0.0001418
+ PS=0.000142 NRD=0.0233214 NRS=0.0281481
M6 VDD 10 7 VDD P L=8e-07 W=5.1e-06 AD=1.632e-11 AS=1.479e-11 PD=1.66e-05
+ PS=1.6e-05 NRD=0.248366 NRS=0.313725
M7 VDD 11 9 VDD P L=8e-07 W=1.8e-05 AD=5.47e-11 AS=5.22e-11 PD=4.28e-05
+ PS=4.18e-05 NRD=0.0819444 NRS=0.0888889
M8 7 8 VDD VDD P L=8e-07 W=5.1e-06 AD=1.479e-11 AS=1.632e-11 PD=1.6e-05
+ PS=1.66e-05 NRD=0.248366 NRS=0.313725
M9 14 7 VDD VDD P L=8e-07 W=5e-06 AD=1.45e-11 AS=5.47e-11 PD=1.58e-05
+ PS=4.28e-05 NRD=0.32 NRS=0.282857
M10 45 IO 11 VDD P L=8e-07 W=8.5e-06 AD=8.5e-12 AS=2.465e-11 PD=1.05e-05
+ PS=2.28e-05 NRD=0.117647 NRS=0.188235
M11 VDD 8 45 VDD P L=8e-07 W=8.5e-06 AD=2.465e-11 AS=8.5e-12 PD=2.28e-05
+ PS=1.05e-05 NRD=0.188235 NRS=0.117647
M12 VDD IO 10 VDD P L=8e-07 W=3e-06 AD=9.6e-12 AS=8.7e-12 PD=1.24e-05
+ PS=1.18e-05 NRD=0.366667 NRS=0.533333
M13 8 CORE VDD VDD P L=8e-07 W=3e-06 AD=8.7e-12 AS=9.6e-12 PD=1.18e-05
+ PS=1.24e-05 NRD=0.366667 NRS=0.533333
M14 GROUND 3 4 GROUND N L=8e-07 W=1.52e-05 AD=5.029e-11 AS=4.604e-11 PD=3.88e-05
+ PS=3.78e-05 NRD=0.0986842 NRS=0.107143
M15 CORE1 4 GROUND GROUND N L=8e-07 W=8.5e-06 AD=2.685e-11 AS=5.029e-11
+ PD=2.46e-05 PS=3.88e-05 NRD=0.179412 NRS=0.185128
M16 GROUND 14 PAD GROUND N L=8e-07 W=4.25e-05 AD=3.57e-10 AS=1.2325e-10
+ PD=0.0001018 PS=9.08e-05 NRD=0.0356863 NRS=0.0376471
M17 PAD 14 GROUND GROUND N L=8e-07 W=4.25e-05 AD=1.2325e-10 AS=3.57e-10
+ PD=9.08e-05 PS=0.0001018 NRD=0.0376471 NRS=0.0376471
M18 GROUND VDD 3 GROUND N L=1e-05 W=2e-06 AD=7.86e-12 AS=7.76e-12 PD=1.15e-05
+ PS=1.14e-05 NRD=0.6125 NRS=0.9
M19 GROUND 7 14 GROUND N L=8e-07 W=3e-06 AD=1.98e-11 AS=8.7e-12 PD=1.92e-05
+ PS=1.18e-05 NRD=0.416667 NRS=0.533333
M20 GROUND IO 10 GROUND N L=8e-07 W=2e-06 AD=1.076e-11 AS=9e-12 PD=1.44e-05
+ PS=1.24e-05 NRD=0.725 NRS=1.05
M21 8 CORE GROUND GROUND N L=8e-07 W=2e-06 AD=8.76e-12 AS=1.076e-11 PD=1.24e-05
+ PS=1.44e-05 NRD=0.725 NRS=1.15
M22 46 8 7 GROUND N L=8e-07 W=3.4e-06 AD=2.635e-12 AS=1.054e-11 PD=4.95e-06
+ PS=1.3e-05 NRD=0.227941 NRS=0.529412
M23 9 11 GROUND GROUND N L=8e-07 W=6.1e-06 AD=1.769e-11 AS=1.98e-11 PD=1.8e-05
+ PS=1.92e-05 NRD=0.20765 NRS=0.262295
M24 GROUND 10 46 GROUND N L=8e-07 W=3.4e-06 AD=1.054e-11 AS=2.635e-12 PD=1.3e-05
+ PS=4.95e-06 NRD=0.529412 NRS=0.227941
M25 GROUND 8 11 GROUND N L=8e-07 W=2.8e-06 AD=8.96e-12 AS=8.12e-12 PD=1.2e-05
+ PS=1.14e-05 NRD=0.392857 NRS=0.571429
M26 11 IO GROUND GROUND N L=8e-07 W=2.8e-06 AD=8.12e-12 AS=8.96e-12 PD=1.14e-05
+ PS=1.2e-05 NRD=0.392857 NRS=0.571429
*R27 PAD 3 322.222
XR1 PAD 3 RNW W=45u L=14.5u
D28 GROUND PAD DNWELLPSUB  AREA=0.166945
D29 PAD VDD DPDIFFNWELL  AREA=0.011189
D30 3 VDD DPDIFFNWELL  AREA=0.00322491
D31 GROUND 3 DNDIFFPSUB  AREA=0.0164366
.ends

.subckt IPAD00 GROUND PADIN OUT1 VDD
M0 VDD 3 4 VDD P L=8e-07 W=4.1e-06 AD=7.397e-11 AS=1.189e-11 PD=5.64e-05
+ PS=1.4e-05 NRD=0.341463 NRS=0.390244
M1 OUT1 4 VDD VDD P L=8e-07 W=2.48e-05 AD=7.192e-11 AS=7.397e-11 PD=5.54e-05
+ PS=5.64e-05 NRD=0.0645161 NRS=0.0645161
M2 GROUND 3 4 GROUND N L=8e-07 W=2.2e-06 AD=2.691e-11 AS=7.86e-12 PD=2.46e-05
+ PS=1.14e-05 NRD=0.431818 NRS=0.818182
M3 OUT1 4 GROUND GROUND N L=8e-07 W=8.9e-06 AD=2.581e-11 AS=2.691e-11
+ PD=2.36e-05 PS=2.46e-05 NRD=0.151685 NRS=0.179775
*R4 PADIN 3 322.222
XR1 PADIN 3 RNW W=45u L=14.5u
D5 GROUND PADIN DNWELLPSUB  AREA=0.165684
D6 PADIN VDD DPDIFFNWELL  AREA=0.011189
D7 3 VDD DPDIFFNWELL  AREA=0.00322491
D8 GROUND 3 DNDIFFPSUB  AREA=0.0164366
.ends

.subckt IPPD00 GROUND PADIN VDD OUT1
M0 VDD 3 5 VDD P L=8e-07 W=4.1e-06 AD=7.397e-11 AS=1.189e-11 PD=5.64e-05
+ PS=1.4e-05 NRD=0.300813 NRS=0.390244
M1 OUT1 5 VDD VDD P L=8e-07 W=2.48e-05 AD=7.192e-11 AS=7.397e-11 PD=5.54e-05
+ PS=5.64e-05 NRD=0.0645161 NRS=0.0645161
M2 GROUND 3 5 GROUND N L=8e-07 W=2.2e-06 AD=2.691e-11 AS=7.99e-12 PD=2.46e-05
+ PS=1.15e-05 NRD=0.431818 NRS=0.840909
M3 GROUND VDD 3 GROUND N L=6.4e-06 W=2e-06 AD=8.76e-12 AS=8.76e-12 PD=1.24e-05
+ PS=1.24e-05 NRD=0.725 NRS=1.15
M4 OUT1 5 GROUND GROUND N L=8e-07 W=8.9e-06 AD=2.581e-11 AS=2.691e-11
+ PD=2.36e-05 PS=2.46e-05 NRD=0.151685 NRS=0.179775
*R5 PADIN 3 322.222
XR1 PADIN 3 RNW W=45u L=14.5u
D6 GROUND PADIN DNWELLPSUB  AREA=0.165684
D7 PADIN VDD DPDIFFNWELL  AREA=0.011189
D8 3 VDD DPDIFFNWELL  AREA=0.00322491
D9 GROUND 3 DNDIFFPSUB  AREA=0.0164366
.ends

.subckt IPPU00 GROUND PADIN OUT1 VDD
M0 VDD GROUND 3 VDD P L=4e-06 W=5e-06 AD=1.8e-11 AS=1.8e-11 PD=1.72e-05
+ PS=1.72e-05 NRD=0.29 NRS=0.46
M1 VDD 3 4 VDD P L=8e-07 W=4.1e-06 AD=7.397e-11 AS=1.189e-11 PD=5.64e-05
+ PS=1.4e-05 NRD=0.300813 NRS=0.390244
M2 OUT1 4 VDD VDD P L=8e-07 W=2.48e-05 AD=7.192e-11 AS=7.397e-11 PD=5.54e-05
+ PS=5.64e-05 NRD=0.0645161 NRS=0.0645161
M3 GROUND 3 4 GROUND N L=8e-07 W=2.2e-06 AD=2.691e-11 AS=7.86e-12 PD=2.46e-05
+ PS=1.14e-05 NRD=0.431818 NRS=0.818182
M4 OUT1 4 GROUND GROUND N L=8e-07 W=8.9e-06 AD=2.581e-11 AS=2.691e-11
+ PD=2.36e-05 PS=2.46e-05 NRD=0.151685 NRS=0.179775
*R5 PADIN 3 322.222
XR1 PADIN 3 RNW W=45u L=14.5u
D6 GROUND PADIN DNWELLPSUB  AREA=0.165684
D7 PADIN VDD DPDIFFNWELL  AREA=0.011189
D8 3 VDD DPDIFFNWELL  AREA=0.00322491
D9 GROUND 3 DNDIFFPSUB  AREA=0.0164366
.ends

.subckt IPSH00 GROUND PADIN VDD OUT1
M0 8 3 5 VDD P L=8e-07 W=4.9e-06 AD=2.217e-11 AS=1.421e-11 PD=2.04e-05
+ PS=1.56e-05 NRD=0.285714 NRS=0.326531
M1 VDD 3 8 VDD P L=8e-07 W=6.8e-06 AD=2.108e-11 AS=2.217e-11 PD=1.98e-05
+ PS=2.04e-05 NRD=0.186275 NRS=0.235294
M2 GROUND 5 8 VDD P L=8e-07 W=1.1e-05 AD=3.19e-11 AS=3.19e-11 PD=2.78e-05
+ PS=2.78e-05 NRD=0.127273 NRS=0.145455
M3 OUT1 5 VDD VDD P L=8e-07 W=2.56e-05 AD=8.32e-11 AS=7.424e-11 PD=5.77e-05
+ PS=5.7e-05 NRD=0.0625 NRS=0.0625
M4 6 3 5 GROUND N L=8e-07 W=2.4e-06 AD=9.3e-12 AS=7.83e-12 PD=1.24e-05
+ PS=1.13e-05 NRD=0.458333 NRS=0.729167
M5 GROUND 3 6 GROUND N L=8e-07 W=2.7e-06 AD=7.83e-12 AS=9.3e-12 PD=1.12e-05
+ PS=1.24e-05 NRD=0.407407 NRS=0.703704
M6 OUT1 5 GROUND GROUND N L=8e-07 W=9.2e-06 AD=2.668e-11 AS=2.898e-11
+ PD=2.42e-05 PS=2.47e-05 NRD=0.146739 NRS=0.201087
M7 VDD 5 6 GROUND N L=8e-07 W=3.9e-06 AD=1.404e-11 AS=1.404e-11 PD=1.5e-05
+ PS=1.5e-05 NRD=0.371795 NRS=0.589744
*R8 PADIN 3 322.222
XR1 PADIN 3 RNW W=45u L=14.5u
D9 GROUND PADIN DNWELLPSUB  AREA=0.165684
D10 PADIN VDD DPDIFFNWELL  AREA=0.011189
D11 3 VDD DPDIFFNWELL  AREA=0.00322491
D12 GROUND 3 DNDIFFPSUB  AREA=0.0164366
.ends

.subckt OTPD01 GROUND PAD VDD IN1
M0 PAD 4 VDD VDD P L=8e-07 W=9.275e-05 AD=5.24475e-10 AS=2.68975e-10
+ PD=0.0001973 PS=0.0001913 NRD=0.0260108 NRS=0.0172507
M1 VDD 4 PAD VDD P L=8e-07 W=4.725e-05 AD=1.37025e-10 AS=5.24475e-10
+ PD=0.0001003 PS=0.0001973 NRD=0.0320988 NRS=0.0610733
M2 VDD IN1 4 VDD P L=8e-07 W=2.4e-05 AD=6.96e-11 AS=6.96e-11 PD=5.38e-05
+ PS=5.38e-05 NRD=0.0666667 NRS=0.0666667
M3 PAD 4 GROUND GROUND N L=8e-07 W=4.5e-05 AD=1.305e-10 AS=1.305e-10 PD=9.58e-05
+ PS=9.58e-05 NRD=0.0335354 NRS=0.0355556
M4 GROUND IN1 4 GROUND N L=8e-07 W=8.7e-06 AD=2.523e-11 AS=2.523e-11 PD=2.32e-05
+ PS=2.32e-05 NRD=0.155172 NRS=0.183908
D5 GROUND PAD DNWELLPSUB  AREA=0.158336
.ends

.subckt OTPD02 GROUND PAD VDD IN1
M0 PAD 4 VDD VDD P L=8e-07 W=8.3e-05 AD=2.905e-10 AS=2.407e-10 PD=0.000173
+ PS=0.0001718 NRD=0.0203916 NRS=0.0192771
M1 VDD 4 PAD VDD P L=8e-07 W=8.3e-05 AD=2.905e-10 AS=2.905e-10 PD=0.000173
+ PS=0.000173 NRD=0.0204545 NRS=0.0210843
M2 PAD 4 VDD VDD P L=8e-07 W=8.3e-05 AD=2.6e-10 AS=2.905e-10 PD=0.000173
+ PS=0.000173 NRD=0.0198193 NRS=0.0210843
M3 VDD 4 PAD VDD P L=8e-07 W=2.2e-05 AD=6.6e-11 AS=2.6e-10 PD=5e-05 PS=0.000173
+ NRD=0.0670455 NRS=0.0818182
M4 VDD IN1 4 VDD P L=8e-07 W=3.5e-05 AD=1.015e-10 AS=1.015e-10 PD=7.58e-05
+ PS=7.58e-05 NRD=0.0439286 NRS=0.0457143
M5 PAD 4 GROUND GROUND N L=8e-07 W=6e-05 AD=2.559e-10 AS=1.74e-10 PD=0.0001321
+ PS=0.0001258 NRD=0.0546875 NRS=0.0266667
M6 GROUND 4 PAD GROUND N L=8e-07 W=2.6e-05 AD=7.8e-11 AS=2.559e-10 PD=5.8e-05
+ PS=0.0001321 NRD=0.259615 NRS=0.109615
M7 GROUND IN1 4 GROUND N L=8e-07 W=1.2e-05 AD=3.48e-11 AS=3.48e-11 PD=2.98e-05
+ PS=2.98e-05 NRD=0.119444 NRS=0.133333
D8 GROUND PAD DNWELLPSUB  AREA=0.158336
.ends

.subckt OTPD03 GROUND PAD VDD IN1
M0 PAD 4 VDD VDD P L=8e-07 W=9e-05 AD=3.15e-10 AS=2.61e-10 PD=0.000187
+ PS=0.0001858 NRD=0.0195238 NRS=0.0177778
M1 VDD 4 PAD VDD P L=8e-07 W=9e-05 AD=3.15e-10 AS=3.15e-10 PD=0.000187
+ PS=0.000187 NRD=0.0206452 NRS=0.0188889
M2 PAD 4 VDD VDD P L=8e-07 W=9e-05 AD=3.15e-10 AS=3.15e-10 PD=0.000187
+ PS=0.000187 NRD=0.0195238 NRS=0.0177778
M3 VDD 4 PAD VDD P L=8e-07 W=9e-05 AD=3.15e-10 AS=3.15e-10 PD=0.000187
+ PS=0.000187 NRD=0.0206452 NRS=0.0188889
M4 PAD 4 VDD VDD P L=8e-07 W=9e-05 AD=3.125e-10 AS=3.15e-10 PD=0.000187
+ PS=0.000187 NRD=0.0195238 NRS=0.0177778
M5 VDD 4 PAD VDD P L=8e-07 W=8.5e-05 AD=2.55e-10 AS=3.125e-10 PD=0.000176
+ PS=0.000187 NRD=0.0195686 NRS=0.02
M6 VDD IN1 4 VDD P L=8e-07 W=5.7e-05 AD=1.653e-10 AS=1.653e-10 PD=0.0001198
+ PS=0.0001198 NRD=0.0273954 NRS=0.0280702
M7 PAD 4 GROUND GROUND N L=8e-07 W=6e-05 AD=3.96e-10 AS=1.98e-10 PD=0.0001332
+ PS=0.0001266 NRD=0.0273684 NRS=0.03
M8 GROUND 4 PAD GROUND N L=8e-07 W=6e-05 AD=3.564e-10 AS=3.96e-10 PD=0.0001332
+ PS=0.0001332 NRD=0.0274603 NRS=0.0283333
M9 PAD 4 GROUND GROUND N L=8e-07 W=4.8e-05 AD=1.584e-10 AS=3.564e-10
+ PD=0.0001026 PS=0.0001332 NRD=0.0410714 NRS=0.0336454
M10 GROUND IN1 4 GROUND N L=8e-07 W=1.88e-05 AD=5.452e-11 AS=5.452e-11
+ PD=4.34e-05 PS=4.34e-05 NRD=0.0791962 NRS=0.0851064
D11 GROUND PAD DNWELLPSUB  AREA=0.158336
.ends

.subckt OTPD04 GROUND PAD VDD IN1
M0 PAD 4 VDD VDD P L=8e-07 W=8.155e-05 AD=2.85425e-10 AS=2.36495e-10
+ PD=0.0001701 PS=0.0001689 NRD=0.0215468 NRS=0.0196199
M1 VDD 4 PAD VDD P L=8e-07 W=8.155e-05 AD=2.85425e-10 AS=2.85425e-10
+ PD=0.0001701 PS=0.0001701 NRD=0.0227489 NRS=0.0208461
M2 PAD 4 VDD VDD P L=8e-07 W=8.155e-05 AD=2.85425e-10 AS=2.85425e-10
+ PD=0.0001701 PS=0.0001701 NRD=0.0215468 NRS=0.0196199
M3 VDD 4 PAD VDD P L=8e-07 W=8.155e-05 AD=2.85425e-10 AS=2.85425e-10
+ PD=0.0001701 PS=0.0001701 NRD=0.0227489 NRS=0.0208461
M4 PAD 4 VDD VDD P L=8e-07 W=8.155e-05 AD=2.85425e-10 AS=2.85425e-10
+ PD=0.0001701 PS=0.0001701 NRD=0.0215468 NRS=0.0196199
M5 VDD 4 PAD VDD P L=8e-07 W=8.155e-05 AD=2.85425e-10 AS=2.85425e-10
+ PD=0.0001701 PS=0.0001701 NRD=0.020381 NRS=0.0208461
M6 PAD 4 VDD VDD P L=8e-07 W=8.155e-05 AD=2.85425e-10 AS=2.85425e-10
+ PD=0.0001701 PS=0.0001701 NRD=0.0215468 NRS=0.0220723
M7 VDD 4 PAD VDD P L=8e-07 W=8.155e-05 AD=2.85425e-10 AS=2.85425e-10
+ PD=0.0001701 PS=0.0001701 NRD=0.0227489 NRS=0.0208461
M8 PAD 4 VDD VDD P L=8e-07 W=8.155e-05 AD=2.85425e-10 AS=2.85425e-10
+ PD=0.0001701 PS=0.0001701 NRD=0.0215468 NRS=0.0196199
M9 VDD 4 PAD VDD P L=8e-07 W=8.155e-05 AD=2.85425e-10 AS=2.85425e-10
+ PD=0.0001701 PS=0.0001701 NRD=0.0227489 NRS=0.0208461
M10 PAD 4 VDD VDD P L=8e-07 W=8.155e-05 AD=2.85425e-10 AS=2.85425e-10
+ PD=0.0001701 PS=0.0001701 NRD=0.0215468 NRS=0.0196199
M11 VDD 4 PAD VDD P L=8e-07 W=8.155e-05 AD=2.8517e-10 AS=2.85425e-10
+ PD=0.0001701 PS=0.0001701 NRD=0.020381 NRS=0.0208461
M12 PAD 4 VDD VDD P L=8e-07 W=8.14e-05 AD=2.5234e-10 AS=2.8517e-10 PD=0.000169
+ PS=0.0001701 NRD=0.0215865 NRS=0.022113
M13 4 IN1 VDD VDD P L=8e-07 W=6.2e-05 AD=2.046e-10 AS=2.294e-10 PD=0.0001306
+ PS=0.0001314 NRD=0.0268076 NRS=0.0370968
M14 VDD IN1 4 VDD P L=8e-07 W=6.2e-05 AD=1.798e-10 AS=2.046e-10 PD=0.0001298
+ PS=0.0001306 NRD=0.0252503 NRS=0.0258065
M15 PAD 4 GROUND GROUND N L=8e-07 W=5.535e-05 AD=3.6531e-10 AS=1.82655e-10
+ PD=0.0001239 PS=0.0001173 NRD=0.02972 NRS=0.0325203
M16 GROUND 4 PAD GROUND N L=8e-07 W=5.535e-05 AD=3.6531e-10 AS=3.6531e-10
+ PD=0.0001239 PS=0.0001239 NRD=0.02972 NRS=0.0307136
M17 PAD 4 GROUND GROUND N L=8e-07 W=5.535e-05 AD=2.13097e-10 AS=3.6531e-10
+ PD=0.0001184 PS=0.0001239 NRD=0.0344173 NRS=0.0315694
M18 GROUND 4 PAD GROUND N L=8e-07 W=5.535e-05 AD=2.1033e-10 AS=2.13097e-10
+ PD=0.0001183 PS=0.0001184 NRD=0.034869 NRS=0.0338991
M19 PAD 4 GROUND GROUND N L=8e-07 W=5.535e-05 AD=3.6512e-10 AS=2.1033e-10
+ PD=0.0001239 PS=0.0001183 NRD=0.032159 NRS=0.0325203
M20 GROUND 4 PAD GROUND N L=8e-07 W=5.525e-05 AD=3.48075e-10 AS=3.6512e-10
+ PD=0.0001231 PS=0.0001239 NRD=0.0297738 NRS=0.0307692
M21 GROUND IN1 4 GROUND N L=8e-07 W=4e-05 AD=1.16e-10 AS=1.16e-10 PD=8.58e-05
+ PS=8.58e-05 NRD=0.0386842 NRS=0.04
D22 GROUND PAD DNWELLPSUB  AREA=0.158336
.ends

.subckt OTTR01 GROUND PAD EN IN1 VDD
M0 PAD 5 VDD VDD P L=8e-07 W=7e-05 AD=2.45e-10 AS=2.03e-10 PD=0.000147
+ PS=0.0001458 NRD=0.0228571 NRS=0.0228571
M1 VDD 5 PAD VDD P L=8e-07 W=7e-05 AD=2.03e-10 AS=2.45e-10 PD=0.0001458
+ PS=0.000147 NRD=0.0224107 NRS=0.0271429
M2 VDD 6 3 VDD P L=8e-07 W=3e-06 AD=9.6e-12 AS=8.7e-12 PD=1.24e-05 PS=1.18e-05
+ NRD=0.366667 NRS=0.533333
M3 VDD 9 5 VDD P L=8e-07 W=1.1e-05 AD=3.375e-11 AS=3.19e-11 PD=2.88e-05
+ PS=2.78e-05 NRD=0.127273 NRS=0.145455
M4 3 4 VDD VDD P L=8e-07 W=3e-06 AD=8.7e-12 AS=9.6e-12 PD=1.18e-05 PS=1.24e-05
+ NRD=0.366667 NRS=0.533333
M5 10 3 VDD VDD P L=8e-07 W=3.7e-06 AD=1.073e-11 AS=3.375e-11 PD=1.32e-05
+ PS=2.88e-05 NRD=0.297297 NRS=0.486486
M6 31 EN 9 VDD P L=8e-07 W=4.3e-06 AD=4.3e-12 AS=1.247e-11 PD=6.3e-06
+ PS=1.44e-05 NRD=0.232558 NRS=0.372093
M7 VDD 4 31 VDD P L=8e-07 W=4.3e-06 AD=1.247e-11 AS=4.3e-12 PD=1.44e-05
+ PS=6.3e-06 NRD=0.372093 NRS=0.232558
M8 VDD EN 6 VDD P L=8e-07 W=3e-06 AD=9.6e-12 AS=8.7e-12 PD=1.24e-05 PS=1.18e-05
+ NRD=0.366667 NRS=0.533333
M9 4 IN1 VDD VDD P L=8e-07 W=3e-06 AD=8.7e-12 AS=9.6e-12 PD=1.18e-05 PS=1.24e-05
+ NRD=0.366667 NRS=0.533333
M10 GROUND 10 PAD GROUND N L=8e-07 W=4.4e-05 AD=1.35605e-10 AS=1.2868e-10
+ PD=9.52e-05 PS=9.47e-05 NRD=0.0365909 NRS=0.0368182
M11 GROUND 3 10 GROUND N L=8e-07 W=2.3e-06 AD=1.42e-11 AS=7.91e-12 PD=1.58e-05
+ PS=1.14e-05 NRD=0.413043 NRS=0.782609
M12 GROUND EN 6 GROUND N L=8e-07 W=2e-06 AD=1.076e-11 AS=9e-12 PD=1.44e-05
+ PS=1.24e-05 NRD=0.725 NRS=1.05
M13 4 IN1 GROUND GROUND N L=8e-07 W=2e-06 AD=8.76e-12 AS=1.076e-11 PD=1.24e-05
+ PS=1.44e-05 NRD=0.725 NRS=1.15
M14 32 4 3 GROUND N L=8e-07 W=2e-06 AD=1.75e-12 AS=7.76e-12 PD=3.75e-06
+ PS=1.14e-05 NRD=0.4375 NRS=0.9
M15 5 9 GROUND GROUND N L=8e-07 W=4.5e-06 AD=1.305e-11 AS=1.42e-11 PD=1.48e-05
+ PS=1.58e-05 NRD=0.244444 NRS=0.355556
M16 GROUND 6 32 GROUND N L=8e-07 W=2e-06 AD=7.76e-12 AS=1.75e-12 PD=1.14e-05
+ PS=3.75e-06 NRD=0.9 NRS=0.4375
M17 GROUND 4 9 GROUND N L=8e-07 W=2e-06 AD=8.76e-12 AS=7.76e-12 PD=1.24e-05
+ PS=1.14e-05 NRD=0.6 NRS=0.9
M18 9 EN GROUND GROUND N L=8e-07 W=2e-06 AD=7.76e-12 AS=8.76e-12 PD=1.14e-05
+ PS=1.24e-05 NRD=0.6 NRS=0.9
D19 GROUND PAD DNWELLPSUB  AREA=0.158336
.ends

.subckt OTTR02 GROUND PAD EN IN1 VDD
M0 PAD 5 VDD VDD P L=8e-07 W=7e-05 AD=2.45e-10 AS=2.03e-10 PD=0.000147
+ PS=0.0001458 NRD=0.0228571 NRS=0.0228571
M1 VDD 5 PAD VDD P L=8e-07 W=7e-05 AD=2.45e-10 AS=2.45e-10 PD=0.000147
+ PS=0.000147 NRD=0.0224107 NRS=0.0271429
M2 PAD 5 VDD VDD P L=8e-07 W=7e-05 AD=2.4e-10 AS=2.45e-10 PD=0.000147
+ PS=0.000147 NRD=0.0228571 NRS=0.0271429
M3 VDD 5 PAD VDD P L=8e-07 W=6e-05 AD=1.74e-10 AS=2.4e-10 PD=0.0001258
+ PS=0.000147 NRD=0.0260714 NRS=0.0316667
M4 VDD 6 3 VDD P L=8e-07 W=5.1e-06 AD=1.632e-11 AS=1.479e-11 PD=1.66e-05
+ PS=1.6e-05 NRD=0.248366 NRS=0.313725
M5 VDD 9 5 VDD P L=8e-07 W=1.8e-05 AD=5.47e-11 AS=5.22e-11 PD=4.28e-05
+ PS=4.18e-05 NRD=0.0819444 NRS=0.0888889
M6 3 4 VDD VDD P L=8e-07 W=5.1e-06 AD=1.479e-11 AS=1.632e-11 PD=1.6e-05
+ PS=1.66e-05 NRD=0.248366 NRS=0.313725
M7 10 3 VDD VDD P L=8e-07 W=5e-06 AD=1.45e-11 AS=5.47e-11 PD=1.58e-05
+ PS=4.28e-05 NRD=0.32 NRS=0.292075
M8 33 EN 9 VDD P L=8e-07 W=8.5e-06 AD=8.5e-12 AS=2.465e-11 PD=1.05e-05
+ PS=2.28e-05 NRD=0.117647 NRS=0.188235
M9 VDD 4 33 VDD P L=8e-07 W=8.5e-06 AD=2.465e-11 AS=8.5e-12 PD=2.28e-05
+ PS=1.05e-05 NRD=0.188235 NRS=0.117647
M10 VDD EN 6 VDD P L=8e-07 W=3e-06 AD=9.6e-12 AS=8.7e-12 PD=1.24e-05 PS=1.18e-05
+ NRD=0.366667 NRS=0.533333
M11 4 IN1 VDD VDD P L=8e-07 W=3e-06 AD=8.7e-12 AS=9.6e-12 PD=1.18e-05
+ PS=1.24e-05 NRD=0.366667 NRS=0.533333
M12 GROUND 10 PAD GROUND N L=8e-07 W=4.25e-05 AD=3.57e-10 AS=1.2325e-10
+ PD=0.0001018 PS=9.08e-05 NRD=0.0356863 NRS=0.0376471
M13 PAD 10 GROUND GROUND N L=8e-07 W=4.25e-05 AD=1.2325e-10 AS=3.57e-10
+ PD=9.08e-05 PS=0.0001018 NRD=0.0376471 NRS=0.0376471
M14 GROUND 3 10 GROUND N L=8e-07 W=3e-06 AD=1.919e-11 AS=8.7e-12 PD=1.9e-05
+ PS=1.18e-05 NRD=0.4 NRS=0.533333
M15 GROUND EN 6 GROUND N L=8e-07 W=2e-06 AD=1.076e-11 AS=9e-12 PD=1.44e-05
+ PS=1.24e-05 NRD=0.725 NRS=1.05
M16 4 IN1 GROUND GROUND N L=8e-07 W=2e-06 AD=8.76e-12 AS=1.076e-11 PD=1.24e-05
+ PS=1.44e-05 NRD=0.725 NRS=1.15
M17 34 4 3 GROUND N L=8e-07 W=3.4e-06 AD=2.975e-12 AS=1.054e-11 PD=5.15e-06
+ PS=1.3e-05 NRD=0.257353 NRS=0.529412
M18 5 9 GROUND GROUND N L=8e-07 W=6.1e-06 AD=1.769e-11 AS=1.919e-11 PD=1.8e-05
+ PS=1.9e-05 NRD=0.20765 NRS=0.262295
M19 GROUND 6 34 GROUND N L=8e-07 W=3.4e-06 AD=1.054e-11 AS=2.975e-12 PD=1.3e-05
+ PS=5.15e-06 NRD=0.529412 NRS=0.257353
M20 GROUND 4 9 GROUND N L=8e-07 W=2.8e-06 AD=8.96e-12 AS=8.12e-12 PD=1.2e-05
+ PS=1.14e-05 NRD=0.392857 NRS=0.571429
M21 9 EN GROUND GROUND N L=8e-07 W=2.8e-06 AD=8.12e-12 AS=8.96e-12 PD=1.14e-05
+ PS=1.2e-05 NRD=0.392857 NRS=0.571429
D22 GROUND PAD DNWELLPSUB  AREA=0.158336
.ends

.subckt OTTR03 GROUND PAD EN IN1 VDD
M0 PAD 5 VDD VDD P L=8e-07 W=7e-05 AD=2.45e-10 AS=2.03e-10 PD=0.000147
+ PS=0.0001458 NRD=0.0228571 NRS=0.0228571
M1 VDD 5 PAD VDD P L=8e-07 W=7e-05 AD=2.45e-10 AS=2.45e-10 PD=0.000147
+ PS=0.000147 NRD=0.0224107 NRS=0.0271429
M2 PAD 5 VDD VDD P L=8e-07 W=7e-05 AD=2.3825e-10 AS=2.45e-10 PD=0.000147
+ PS=0.000147 NRD=0.0228571 NRS=0.0271429
M3 VDD 5 PAD VDD P L=8e-07 W=5.65e-05 AD=3.051e-10 AS=2.3825e-10 PD=0.0001238
+ PS=0.000147 NRD=0.0276378 NRS=0.0334031
M4 PAD 5 VDD VDD P L=8e-07 W=5.65e-05 AD=2.3825e-10 AS=3.051e-10 PD=0.000147
+ PS=0.0001238 NRD=0.0315044 NRS=0.0283186
M5 VDD 5 PAD VDD P L=8e-07 W=7e-05 AD=2.45e-10 AS=2.3825e-10 PD=0.000147
+ PS=0.000147 NRD=0.0265625 NRS=0.0228571
M6 PAD 5 VDD VDD P L=8e-07 W=7e-05 AD=2.45e-10 AS=2.45e-10 PD=0.000147
+ PS=0.000147 NRD=0.0271429 NRS=0.0228571
M7 VDD 5 PAD VDD P L=8e-07 W=7e-05 AD=2.03e-10 AS=2.45e-10 PD=0.0001458
+ PS=0.000147 NRD=0.0224107 NRS=0.0228571
M8 VDD 6 3 VDD P L=8e-07 W=3e-06 AD=9.6e-12 AS=8.7e-12 PD=1.24e-05 PS=1.18e-05
+ NRD=0.366667 NRS=0.533333
M9 VDD 7 5 VDD P L=8e-07 W=4.73e-05 AD=1.4387e-10 AS=1.3717e-10 PD=0.0001014
+ PS=0.0001004 NRD=0.0327696 NRS=0.0338266
M10 3 4 VDD VDD P L=8e-07 W=3e-06 AD=8.7e-12 AS=9.6e-12 PD=1.18e-05 PS=1.24e-05
+ NRD=0.366667 NRS=0.533333
M11 10 3 VDD VDD P L=8e-07 W=1.34e-05 AD=3.886e-11 AS=1.4387e-10 PD=3.26e-05
+ PS=0.0001014 NRD=0.106965 NRS=0.134328
M12 35 EN 7 VDD P L=8e-07 W=1.22e-05 AD=1.22e-11 AS=3.538e-11 PD=1.42e-05
+ PS=3.02e-05 NRD=0.0819672 NRS=0.131148
M13 VDD 4 35 VDD P L=8e-07 W=1.22e-05 AD=3.538e-11 AS=1.22e-11 PD=3.02e-05
+ PS=1.42e-05 NRD=0.131148 NRS=0.0819672
M14 VDD EN 6 VDD P L=8e-07 W=3e-06 AD=9.6e-12 AS=8.7e-12 PD=1.24e-05 PS=1.18e-05
+ NRD=0.366667 NRS=0.533333
M15 4 IN1 VDD VDD P L=8e-07 W=3e-06 AD=8.7e-12 AS=9.6e-12 PD=1.18e-05
+ PS=1.24e-05 NRD=0.366667 NRS=0.533333
M16 GROUND 10 PAD GROUND N L=8e-07 W=7e-05 AD=5.88e-10 AS=2.03e-10 PD=0.0001568
+ PS=0.0001458 NRD=0.0220635 NRS=0.0228571
M17 PAD 10 GROUND GROUND N L=8e-07 W=7e-05 AD=2.2185e-10 AS=5.88e-10
+ PD=0.0001471 PS=0.0001568 NRD=0.0219643 NRS=0.0228571
M18 GROUND 10 PAD GROUND N L=8e-07 W=2.9e-05 AD=1.0005e-10 AS=2.2185e-10
+ PD=6.49e-05 PS=0.0001471 NRD=0.0741379 NRS=0.0623054
M19 GROUND 3 10 GROUND N L=8e-07 W=5e-06 AD=6.05e-11 AS=1.45e-11 PD=4.68e-05
+ PS=1.58e-05 NRD=0.28 NRS=0.32
M20 GROUND EN 6 GROUND N L=8e-07 W=2e-06 AD=1.076e-11 AS=9e-12 PD=1.44e-05
+ PS=1.24e-05 NRD=0.725 NRS=1.05
M21 4 IN1 GROUND GROUND N L=8e-07 W=2e-06 AD=8.76e-12 AS=1.076e-11 PD=1.24e-05
+ PS=1.44e-05 NRD=0.725 NRS=1.15
M22 36 4 3 GROUND N L=8e-07 W=2e-06 AD=1.75e-12 AS=7.76e-12 PD=3.75e-06
+ PS=1.14e-05 NRD=0.4375 NRS=0.9
M23 5 7 GROUND GROUND N L=8e-07 W=2e-05 AD=5.8e-11 AS=6.05e-11 PD=4.58e-05
+ PS=4.68e-05 NRD=0.0744444 NRS=0.08
M24 GROUND 6 36 GROUND N L=8e-07 W=2e-06 AD=7.76e-12 AS=1.75e-12 PD=1.14e-05
+ PS=3.75e-06 NRD=0.9 NRS=0.4375
M25 GROUND 4 7 GROUND N L=8e-07 W=3.2e-06 AD=1.024e-11 AS=9.28e-12 PD=1.28e-05
+ PS=1.22e-05 NRD=0.34375 NRS=0.5
M26 7 EN GROUND GROUND N L=8e-07 W=3.2e-06 AD=9.28e-12 AS=1.024e-11 PD=1.22e-05
+ PS=1.28e-05 NRD=0.34375 NRS=0.5
D27 GROUND PAD DNWELLPSUB  AREA=0.158336
.ends

.subckt PVDD01  VDD GROUND
D0 GROUND VDD DNWELLPSUB  AREA=0.133559
.ends

.subckt PVSS01 GROUND VDD
D0 GROUND GROUND DNWELLPSUB  AREA=0.133559
.ends

.subckt SPAD00 GROUND PADIN OUT1 VDD
*R0 PADIN OUT1 322.222
XR1 PADIN OUT1 RNW W=45u L=14.5u
D1 GROUND PADIN DNWELLPSUB  AREA=0.165684
D2 PADIN VDD DPDIFFNWELL  AREA=0.011189
D3 OUT1 VDD DPDIFFNWELL  AREA=0.00322491
D4 GROUND OUT1 DNDIFFPSUB  AREA=0.0164366
.ends

.SUBCKT RNW N1 N2  W='W' L='L'
R1 N1 N2 '1000*(L/W)' RNW
.ENDS RNW

.SUBCKT RPP N1 N2  W='W' L='L'
R1 N1 N2   '28*(L/W)' RPP
.ENDS RPP

.SUBCKT RPN N1 N2  W='W' L='L'
R1 N1 N2   '22*(L/W)' RPN
.ENDS RPN

.SUBCKT RDIFFN N1 N2  W='W' L='L'
R1 N1 N2   '33*(L/W)' RDIFFN
.ENDS RDIFFN

.SUBCKT RDIFFP N1 N2  W='W' L='L'
R1 N1 N2   '83*(L/W)' RDIFFP
.ENDS RDIFFP

.SUBCKT frame4mmx4mm PAD1 PAD2 PAD3 PAD4 PAD5 PAD6 PAD7 PAD8 PAD9 PAD10 PAD11 PAD12 PAD13 PAD14 PAD15 PAD16 PAD17 PAD18 PAD19 PAD20 PAD21 PAD22 PAD23 PAD24 PAD25 PAD26 PAD27 PAD28 PAD29 PAD30 PAD31 PAD32 PAD2_OUT PAD4_OUT PAD6_OUT PAD8_OUT PAD10_OUT PAD12_OUT PAD14_OUT PAD16_OUT PAD18_OUT PAD20_OUT PAD22_OUT PAD24_OUT PAD26_OUT PAD28_OUT PAD30_OUT PAD32_OUT VDD GROUND

x1  GROUND PAD1 VDD ASPAD00
x2  GROUND PAD2 PAD2_OUT VDD SPAD00
x3  GROUND PAD3 VDD ASPAD00
x4  GROUND PAD4 PAD4_OUT VDD SPAD00
x5  GROUND PAD5 VDD ASPAD00
x6  GROUND PAD6 PAD6_OUT VDD SPAD00
x7  GROUND PAD7 VDD ASPAD00
x8  GROUND PAD8 PAD8_OUT VDD SPAD00
x9  GROUND PAD9 VDD ASPAD00
x10  GROUND PAD10 PAD10_OUT VDD SPAD00
x11  GROUND PAD11 VDD ASPAD00
x12  GROUND PAD12 PAD12_OUT VDD SPAD00
x13  GROUND PAD13 VDD ASPAD00
x14  GROUND PAD14 PAD14_OUT VDD SPAD00
x15  GROUND PAD15 VDD ASPAD00
x16  GROUND PAD16 PAD16_OUT VDD SPAD00
x17  GROUND PAD17 VDD ASPAD00
x18  GROUND PAD18 PAD18_OUT VDD SPAD00
x19  GROUND PAD19 VDD ASPAD00
x20  GROUND PAD20 PAD20_OUT VDD SPAD00
x21  GROUND PAD21 VDD ASPAD00
x22  GROUND PAD22 PAD22_OUT VDD SPAD00
x23  GROUND PAD23 VDD ASPAD00
x24  GROUND PAD24 PAD24_OUT VDD SPAD00
x25  GROUND PAD25 VDD ASPAD00
x26  GROUND PAD26 PAD26_OUT VDD SPAD00
x27  GROUND PAD27 VDD ASPAD00
x28  GROUND PAD28 PAD28_OUT VDD SPAD00
x29  GROUND PAD29 VDD ASPAD00
x30  GROUND PAD30 PAD30_OUT VDD SPAD00
x31  GROUND PAD31 VDD ASPAD00
x32  GROUND PAD32 PAD32_OUT VDD SPAD00

x33  VDD GROUND PVDD01
x34  GROUND VDD PVSS01
x35  VDD GROUND PVDD01
x36  GROUND VDD PVSS01
x37  VDD GROUND PVDD01
x38  GROUND VDD PVSS01
x39  VDD GROUND PVDD01
x40  GROUND VDD PVSS01

.ends frame4mmx4mm

.subckt VDDCON VDD GROUND

.ends

.subckt VSSCON GROUND VDD

.ends

.subckt FILLER1 GROUND VDD
.ends

.subckt FILLER2 GROUND VDD
.ends

.subckt FILLER3 GROUND VDD
.ends

.subckt FILLER4 GROUND VDD
.ends

.subckt FILLER5 GROUND VDD
.ends

.subckt FILLER6 GROUND VDD
.ends

.subckt CORNER GROUND VDD
.ends

.subckt ADNR00 IN2 IN1 IN3 OUT1 VDD GROUND
M0 7 IN2 VDD VDD P L=8e-07 W=5.8e-06 AD=1.856e-11 AS=2.46e-11 PD=1.8e-05
+ PS=2.12e-05 NRD=0.189655 NRS=0.281609
M1 VDD IN1 7 VDD P L=8e-07 W=5.8e-06 AD=2.74e-11 AS=1.856e-11 PD=2.2e-05
+ PS=1.8e-05 NRD=0.237069 NRS=0.275862
M2 OUT1 IN3 7 VDD P L=8e-07 W=5.8e-06 AD=1.682e-11 AS=1.682e-11 PD=1.74e-05
+ PS=1.74e-05 NRD=0.218391 NRS=0.275862
M3 11 IN2 GROUND GROUND N L=8e-07 W=2.9e-06 AD=1.45e-12 AS=8.41e-12 PD=3.9e-06
+ PS=1.16e-05 NRD=0.172414 NRS=0.551724
M4 OUT1 IN1 11 GROUND N L=8e-07 W=2.9e-06 AD=9.28e-12 AS=1.45e-12 PD=1.22e-05
+ PS=3.9e-06 NRD=0.551724 NRS=0.172414
M5 GROUND IN3 OUT1 GROUND N L=8e-07 W=2.9e-06 AD=8.41e-12 AS=9.28e-12
+ PD=1.16e-05 PS=1.22e-05 NRD=0.37931 NRS=0.551724
.ends

.subckt ADR100 A B CIN SOUT COUT VDD GROUND
M0 VDD A 13 VDD P L=8e-07 W=3e-06 AD=9.6e-12 AS=8.7e-12 PD=1.24e-05 PS=1.18e-05
+ NRD=0.366667 NRS=0.533333
M1 2 13 VDD VDD P L=8e-07 W=3e-06 AD=8.7e-12 AS=9.6e-12 PD=1.18e-05 PS=1.24e-05
+ NRD=0.366667 NRS=0.533333
M2 4 2 B VDD P L=8e-07 W=3e-06 AD=1.155e-11 AS=8.7e-12 PD=1.37e-05 PS=1.18e-05
+ NRD=0.425 NRS=0.533333
M3 2 B 4 VDD P L=8e-07 W=3e-06 AD=8.7e-12 AS=1.155e-11 PD=1.18e-05 PS=1.37e-05
+ NRD=0.366667 NRS=0.633333
M4 VDD 4 5 VDD P L=8e-07 W=3e-06 AD=9.6e-12 AS=9.6e-12 PD=1.24e-05 PS=1.24e-05
+ NRD=0.366667 NRS=0.633333
M5 6 CIN VDD VDD P L=8e-07 W=3e-06 AD=1.02e-11 AS=9.6e-12 PD=1.28e-05
+ PS=1.24e-05 NRD=0.45 NRS=0.533333
M6 8 5 CIN VDD P L=8e-07 W=3e-06 AD=1.245e-11 AS=9.9e-12 PD=1.43e-05 PS=1.26e-05
+ NRD=0.458333 NRS=0.666667
M7 6 4 8 VDD P L=8e-07 W=3e-06 AD=9.6e-12 AS=1.245e-11 PD=1.24e-05 PS=1.43e-05
+ NRD=0.416667 NRS=0.666667
M8 VDD 8 SOUT VDD P L=8e-07 W=3.3e-06 AD=9.57e-12 AS=1.914e-11 PD=1.24e-05
+ PS=1.82e-05 NRD=0.333333 NRS=0.606061
M9 10 5 6 VDD P L=8e-07 W=3e-06 AD=1.2e-11 AS=1.035e-11 PD=1.4e-05 PS=1.29e-05
+ NRD=0.433333 NRS=0.716667
M10 11 4 10 VDD P L=8e-07 W=3e-06 AD=1.65e-11 AS=1.2e-11 PD=1.7e-05 PS=1.4e-05
+ NRD=0.65 NRS=0.666667
M11 VDD B 11 VDD P L=8e-07 W=3e-06 AD=8.7e-12 AS=1.65e-11 PD=1.18e-05 PS=1.7e-05
+ NRD=0.366667 NRS=0.733333
M12 VDD 10 COUT VDD P L=8e-07 W=3.1e-06 AD=8.99e-12 AS=1.798e-11 PD=1.2e-05
+ PS=1.78e-05 NRD=0.354839 NRS=0.645161
M13 GROUND A 13 GROUND N L=8e-07 W=2e-06 AD=8.24e-12 AS=7.5e-12 PD=1.2e-05
+ PS=1.12e-05 NRD=0.575 NRS=0.85
M14 2 13 GROUND GROUND N L=8e-07 W=2e-06 AD=7.5e-12 AS=8.24e-12 PD=1.12e-05
+ PS=1.2e-05 NRD=0.575 NRS=0.85
M15 4 13 B GROUND N L=8e-07 W=2e-06 AD=1.642e-11 AS=8.28e-12 PD=1.79e-05
+ PS=1.18e-05 NRD=1.2375 NRS=0.95
M16 13 B 4 GROUND N L=8e-07 W=2e-06 AD=1.726e-11 AS=1.642e-11 PD=1.86e-05
+ PS=1.79e-05 NRD=0.9 NRS=0.9
M17 GROUND 4 5 GROUND N L=8e-07 W=2e-06 AD=9.28e-12 AS=7.96e-12 PD=1.28e-05
+ PS=1.16e-05 NRD=0.475 NRS=0.95
M18 6 CIN GROUND GROUND N L=8e-07 W=2e-06 AD=7.76e-12 AS=9.28e-12 PD=1.14e-05
+ PS=1.28e-05 NRD=0.9 NRS=0.5625
M19 8 4 CIN GROUND N L=8e-07 W=2e-06 AD=9.36e-12 AS=7.76e-12 PD=1.3e-05
+ PS=1.14e-05 NRD=0.625 NRS=0.9
M20 6 5 8 GROUND N L=8e-07 W=2e-06 AD=7.96e-12 AS=9.36e-12 PD=1.16e-05
+ PS=1.3e-05 NRD=0.625 NRS=1
M21 SOUT 8 GROUND GROUND N L=8e-07 W=2e-06 AD=7.76e-12 AS=7.76e-12 PD=1.14e-05
+ PS=1.14e-05 NRD=0.6 NRS=0.9
M22 10 4 6 GROUND N L=8e-07 W=2e-06 AD=9.36e-12 AS=7.76e-12 PD=1.3e-05
+ PS=1.14e-05 NRD=0.625 NRS=0.9
M23 11 5 10 GROUND N L=8e-07 W=2e-06 AD=1.059e-11 AS=9.36e-12 PD=1.42e-05
+ PS=1.3e-05 NRD=0.8125 NRS=1
M24 GROUND B 11 GROUND N L=8e-07 W=2e-06 AD=7.76e-12 AS=1.059e-11 PD=1.14e-05
+ PS=1.42e-05 NRD=0.6 NRS=0.9
M25 COUT 10 GROUND GROUND N L=8e-07 W=2e-06 AD=7.76e-12 AS=7.76e-12 PD=1.14e-05
+ PS=1.14e-05 NRD=0.6 NRS=0.9
.ends

.subckt AND200 IN2 IN1 OUT1 GROUND VDD
M0 5 IN2 VDD VDD P L=8e-07 W=3.1e-06 AD=9.92e-12 AS=8.99e-12 PD=1.26e-05
+ PS=1.2e-05 NRD=0.354839 NRS=0.516129
M1 VDD IN1 5 VDD P L=8e-07 W=3.1e-06 AD=9.87e-12 AS=9.92e-12 PD=1.26e-05
+ PS=1.26e-05 NRD=0.354839 NRS=0.516129
M2 OUT1 5 VDD VDD P L=8e-07 W=3e-06 AD=8.7e-12 AS=9.87e-12 PD=1.18e-05
+ PS=1.26e-05 NRD=0.366667 NRS=0.533333
M3 10 IN2 GROUND GROUND N L=8e-07 W=2.4e-06 AD=2.16e-12 AS=7.96e-12 PD=4.2e-06
+ PS=1.14e-05 NRD=0.375 NRS=0.75
M4 5 IN1 10 GROUND N L=8e-07 W=2.4e-06 AD=7.96e-12 AS=2.16e-12 PD=1.14e-05
+ PS=4.2e-06 NRD=0.75 NRS=0.375
M5 OUT1 5 GROUND GROUND N L=8e-07 W=2e-06 AD=7.76e-12 AS=7.76e-12 PD=1.14e-05
+ PS=1.14e-05 NRD=0.6 NRS=0.9
.ends

.subckt AND201 IN2 IN1 OUT1 GROUND VDD
M0 5 IN2 VDD VDD P L=8e-07 W=3.9e-06 AD=1.248e-11 AS=1.131e-11 PD=1.42e-05
+ PS=1.36e-05 NRD=0.282051 NRS=0.410256
M1 VDD IN1 5 VDD P L=8e-07 W=3.9e-06 AD=1.278e-11 AS=1.248e-11 PD=1.46e-05
+ PS=1.42e-05 NRD=0.282051 NRS=0.410256
M2 OUT1 5 VDD VDD P L=8e-07 W=4.1e-06 AD=1.189e-11 AS=1.278e-11 PD=1.4e-05
+ PS=1.46e-05 NRD=0.268293 NRS=0.390244
M3 10 IN2 GROUND GROUND N L=8e-07 W=3.2e-06 AD=2.88e-12 AS=9.92e-12 PD=5e-06
+ PS=1.26e-05 NRD=0.28125 NRS=0.5625
M4 5 IN1 10 GROUND N L=8e-07 W=3.2e-06 AD=1.044e-11 AS=2.88e-12 PD=1.3e-05
+ PS=5e-06 NRD=0.5625 NRS=0.28125
M5 OUT1 5 GROUND GROUND N L=8e-07 W=2.3e-06 AD=7.91e-12 AS=7.91e-12 PD=1.14e-05
+ PS=1.14e-05 NRD=0.521739 NRS=0.782609
.ends

.subckt AND300 IN3 IN2 IN1 OUT1 GROUND VDD
M0 VDD IN3 7 VDD P L=8e-07 W=3e-06 AD=9.75e-12 AS=8.85e-12 PD=1.25e-05
+ PS=1.19e-05 NRD=0.375 NRS=0.55
M1 7 IN2 VDD VDD P L=8e-07 W=3e-06 AD=9.6e-12 AS=9.75e-12 PD=1.24e-05
+ PS=1.25e-05 NRD=0.366667 NRS=0.533333
M2 VDD IN1 7 VDD P L=8e-07 W=3e-06 AD=9.6e-12 AS=9.6e-12 PD=1.24e-05 PS=1.24e-05
+ NRD=0.366667 NRS=0.533333
M3 OUT1 7 VDD VDD P L=8e-07 W=3e-06 AD=8.7e-12 AS=9.6e-12 PD=1.18e-05
+ PS=1.24e-05 NRD=0.366667 NRS=0.533333
M4 12 IN3 GROUND GROUND N L=8e-07 W=3e-06 AD=6e-12 AS=8.85e-12 PD=7e-06
+ PS=1.19e-05 NRD=0.666667 NRS=0.55
M5 13 IN2 12 GROUND N L=8e-07 W=3e-06 AD=1.95e-12 AS=6e-12 PD=4.3e-06 PS=7e-06
+ NRD=0.216667 NRS=0.666667
M6 7 IN1 13 GROUND N L=8e-07 W=3e-06 AD=1.02e-11 AS=1.95e-12 PD=1.28e-05
+ PS=4.3e-06 NRD=0.7 NRS=0.216667
M7 OUT1 7 GROUND GROUND N L=8e-07 W=2e-06 AD=7.76e-12 AS=7.76e-12 PD=1.14e-05
+ PS=1.14e-05 NRD=0.6 NRS=0.9
.ends

.subckt AND400 IN4 IN3 IN2 IN1 OUT1 GROUND VDD
M0 VDD IN4 8 VDD P L=8e-07 W=4.8e-06 AD=1.536e-11 AS=1.392e-11 PD=1.6e-05
+ PS=1.54e-05 NRD=0.263889 NRS=0.333333
M1 8 IN3 VDD VDD P L=8e-07 W=4.8e-06 AD=1.536e-11 AS=1.536e-11 PD=1.6e-05
+ PS=1.6e-05 NRD=0.263889 NRS=0.333333
M2 VDD IN2 8 VDD P L=8e-07 W=4.8e-06 AD=1.824e-11 AS=1.536e-11 PD=1.72e-05
+ PS=1.6e-05 NRD=0.263889 NRS=0.333333
M3 8 IN1 VDD VDD P L=8e-07 W=4.8e-06 AD=1.392e-11 AS=1.824e-11 PD=1.54e-05
+ PS=1.72e-05 NRD=0.263889 NRS=0.458333
M4 OUT1 8 VDD VDD P L=8e-07 W=3.3e-06 AD=9.57e-12 AS=9.57e-12 PD=1.24e-05
+ PS=1.24e-05 NRD=0.333333 NRS=0.484848
M5 14 IN4 GROUND GROUND N L=8e-07 W=4.1e-06 AD=5.0225e-12 AS=1.189e-11
+ PD=6.55e-06 PS=1.4e-05 NRD=0.29878 NRS=0.390244
M6 15 IN3 14 GROUND N L=8e-07 W=4.1e-06 AD=7.6875e-12 AS=5.0225e-12 PD=7.85e-06
+ PS=6.55e-06 NRD=0.457317 NRS=0.29878
M7 16 IN2 15 GROUND N L=8e-07 W=4.1e-06 AD=3.075e-12 AS=7.6875e-12 PD=5.6e-06
+ PS=7.85e-06 NRD=0.182927 NRS=0.457317
M8 8 IN1 16 GROUND N L=8e-07 W=4.1e-06 AD=1.353e-11 AS=3.075e-12 PD=1.48e-05
+ PS=5.6e-06 NRD=0.439024 NRS=0.182927
M9 OUT1 8 GROUND GROUND N L=8e-07 W=2e-06 AD=7.76e-12 AS=7.76e-12 PD=1.14e-05
+ PS=1.14e-05 NRD=0.6 NRS=0.9
.ends

.subckt AND500 IN5 IN4 IN3 IN2 IN1 OUT1 GROUND VDD
M0 9 IN5 VDD VDD P L=8e-07 W=6e-06 AD=1.92e-11 AS=1.74e-11 PD=1.84e-05
+ PS=1.78e-05 NRD=0.211111 NRS=0.266667
M1 VDD IN4 9 VDD P L=8e-07 W=6e-06 AD=1.92e-11 AS=1.92e-11 PD=1.84e-05
+ PS=1.84e-05 NRD=0.211111 NRS=0.266667
M2 9 IN3 VDD VDD P L=8e-07 W=6e-06 AD=2.22e-11 AS=1.92e-11 PD=1.94e-05
+ PS=1.84e-05 NRD=0.211111 NRS=0.266667
M3 VDD IN2 9 VDD P L=8e-07 W=6e-06 AD=1.98e-11 AS=2.22e-11 PD=1.86e-05
+ PS=1.94e-05 NRD=0.222222 NRS=0.35
M4 9 IN1 VDD VDD P L=8e-07 W=6e-06 AD=1.74e-11 AS=1.98e-11 PD=1.78e-05
+ PS=1.86e-05 NRD=0.211111 NRS=0.266667
M5 VDD 9 OUT1 VDD P L=8e-07 W=3e-06 AD=8.7e-12 AS=8.7e-12 PD=1.18e-05
+ PS=1.18e-05 NRD=0.366667 NRS=0.533333
M6 16 IN5 GROUND GROUND N L=8e-07 W=5.3e-06 AD=6.36e-12 AS=1.537e-11 PD=7.7e-06
+ PS=1.64e-05 NRD=0.226415 NRS=0.301887
M7 17 IN4 16 GROUND N L=8e-07 W=5.3e-06 AD=8.215e-12 AS=6.36e-12 PD=8.4e-06
+ PS=7.7e-06 NRD=0.292453 NRS=0.226415
M8 18 IN3 17 GROUND N L=8e-07 W=5.3e-06 AD=1.961e-11 AS=8.215e-12 PD=1.27e-05
+ PS=8.4e-06 NRD=0.698113 NRS=0.292453
M9 19 IN2 18 GROUND N L=8e-07 W=5.3e-06 AD=3.445e-12 AS=1.961e-11 PD=6.6e-06
+ PS=1.27e-05 NRD=0.122642 NRS=0.698113
M10 9 IN1 19 GROUND N L=8e-07 W=5.3e-06 AD=2.31e-11 AS=3.445e-12 PD=2.11e-05
+ PS=6.6e-06 NRD=0.330189 NRS=0.122642
M11 OUT1 9 GROUND GROUND N L=8e-07 W=2e-06 AD=7.76e-12 AS=7.76e-12 PD=1.14e-05
+ PS=1.14e-05 NRD=0.6 NRS=0.9
.ends

.subckt AOI400 IN1 IN2 IN4 IN3 OUT1 VDD GROUND
M0 VDD IN1 7 VDD P L=8e-07 W=3.1e-06 AD=9.92e-12 AS=8.99e-12 PD=1.26e-05
+ PS=1.2e-05 NRD=0.354839 NRS=0.516129
M1 7 IN2 VDD VDD P L=8e-07 W=3.1e-06 AD=9.92e-12 AS=9.92e-12 PD=1.26e-05
+ PS=1.26e-05 NRD=0.354839 NRS=0.516129
M2 OUT1 IN4 7 VDD P L=8e-07 W=3.1e-06 AD=1.901e-11 AS=9.92e-12 PD=1.94e-05
+ PS=1.26e-05 NRD=0.580645 NRS=0.516129
M3 7 IN3 OUT1 VDD P L=8e-07 W=3.1e-06 AD=8.99e-12 AS=1.901e-11 PD=1.2e-05
+ PS=1.94e-05 NRD=0.516129 NRS=0.580645
M4 13 IN1 OUT1 GROUND N L=8e-07 W=2.9e-06 AD=1.45e-12 AS=8.99e-12 PD=3.9e-06
+ PS=1.2e-05 NRD=0.172414 NRS=0.62069
M5 GROUND IN2 13 GROUND N L=8e-07 W=2.9e-06 AD=3.545e-11 AS=1.45e-12 PD=2.53e-05
+ PS=3.9e-06 NRD=0.448276 NRS=0.172414
M6 14 IN4 GROUND GROUND N L=8e-07 W=2.9e-06 AD=1.595e-12 AS=3.545e-11 PD=4e-06
+ PS=2.53e-05 NRD=0.189655 NRS=0.65252
M7 OUT1 IN3 14 GROUND N L=8e-07 W=2.9e-06 AD=8.41e-12 AS=1.595e-12 PD=1.16e-05
+ PS=4e-06 NRD=0.551724 NRS=0.189655
.ends

.subckt BUFF00 IN1 OUT1 GROUND VDD
M0 VDD IN1 3 VDD P L=8e-07 W=3e-06 AD=1.119e-11 AS=9.3e-12 PD=1.36e-05
+ PS=1.22e-05 NRD=0.4 NRS=0.6
M1 OUT1 3 VDD VDD P L=8e-07 W=3.2e-06 AD=9.92e-12 AS=1.119e-11 PD=1.26e-05
+ PS=1.36e-05 NRD=0.375 NRS=0.5625
M2 GROUND IN1 3 GROUND N L=8e-07 W=2e-06 AD=8.76e-12 AS=7.76e-12 PD=1.24e-05
+ PS=1.14e-05 NRD=0.6 NRS=0.9
M3 OUT1 3 GROUND GROUND N L=8e-07 W=2e-06 AD=7.76e-12 AS=8.76e-12 PD=1.14e-05
+ PS=1.24e-05 NRD=0.6 NRS=0.9
.ends

.subckt CDRI00 IN1 CLKB CLK GROUND VDD
M0 CLKB IN1 VDD VDD P L=8e-07 W=6e-06 AD=1.74e-11 AS=1.74e-11 PD=1.78e-05
+ PS=1.78e-05 NRD=0.211111 NRS=0.266667
M1 CLK CLKB VDD VDD P L=8e-07 W=6e-06 AD=1.74e-11 AS=1.74e-11 PD=1.78e-05
+ PS=1.78e-05 NRD=0.211111 NRS=0.266667
M2 CLKB IN1 GROUND GROUND N L=8e-07 W=3e-06 AD=8.7e-12 AS=8.7e-12 PD=1.18e-05
+ PS=1.18e-05 NRD=0.366667 NRS=0.533333
M3 CLK CLKB GROUND GROUND N L=8e-07 W=3e-06 AD=8.7e-12 AS=8.7e-12 PD=1.18e-05
+ PS=1.18e-05 NRD=0.366667 NRS=0.533333
.ends

.subckt CDRI01 IN1 CLKB CLK VDD GROUND
M0 CLKB IN1 VDD VDD P L=8e-07 W=1.14e-05 AD=3.306e-11 AS=3.306e-11 PD=2.86e-05
+ PS=2.86e-05 NRD=0.111111 NRS=0.140351
M1 CLK CLKB VDD VDD P L=8e-07 W=1.04e-05 AD=3.016e-11 AS=3.016e-11 PD=2.66e-05
+ PS=2.66e-05 NRD=0.121795 NRS=0.153846
M2 CLKB IN1 GROUND GROUND N L=8e-07 W=4.7e-06 AD=1.243e-11 AS=1.363e-11
+ PD=1.63e-05 PS=1.52e-05 NRD=0.244681 NRS=0.340426
M3 CLK CLKB GROUND GROUND N L=8e-07 W=4.3e-06 AD=1.247e-11 AS=1.3545e-11
+ PD=1.44e-05 PS=1.49e-05 NRD=0.255814 NRS=0.372093
.ends

.subckt DC2400 A1 OUT3 A0 OUT2 EN OUT0 OUT1 GROUND VDD
M0 VDD A1 OUT3 VDD P L=8e-07 W=3e-06 AD=1.868e-11 AS=8.7e-12 PD=1.92e-05
+ PS=1.18e-05 NRD=0.6 NRS=0.533333
M1 OUT3 A0 VDD VDD P L=8e-07 W=3e-06 AD=9.9e-12 AS=1.868e-11 PD=1.26e-05
+ PS=1.92e-05 NRD=0.566667 NRS=0.6
M2 VDD EN OUT3 VDD P L=8e-07 W=3e-06 AD=9.6e-12 AS=9.9e-12 PD=1.24e-05
+ PS=1.26e-05 NRD=0.366667 NRS=0.533333
M3 OUT2 EN VDD VDD P L=8e-07 W=3e-06 AD=9.9e-12 AS=9.6e-12 PD=1.26e-05
+ PS=1.24e-05 NRD=0.366667 NRS=0.533333
M4 VDD 7 OUT2 VDD P L=8e-07 W=3e-06 AD=1.868e-11 AS=9.9e-12 PD=1.92e-05
+ PS=1.26e-05 NRD=0.6 NRS=0.566667
M5 OUT2 A1 VDD VDD P L=8e-07 W=3e-06 AD=8.7e-12 AS=1.868e-11 PD=1.18e-05
+ PS=1.92e-05 NRD=0.533333 NRS=0.6
M6 VDD A1 5 VDD P L=8e-07 W=3e-06 AD=8.7e-12 AS=1.2e-11 PD=1.18e-05 PS=1.4e-05
+ NRD=0.366667 NRS=0.9
M7 7 A0 VDD VDD P L=8e-07 W=3e-06 AD=8.7e-12 AS=8.7e-12 PD=1.18e-05 PS=1.18e-05
+ NRD=0.366667 NRS=0.533333
M8 VDD 5 OUT0 VDD P L=8e-07 W=3e-06 AD=1.948e-11 AS=8.7e-12 PD=1.98e-05
+ PS=1.18e-05 NRD=0.6 NRS=0.533333
M9 OUT0 7 VDD VDD P L=8e-07 W=3e-06 AD=9.9e-12 AS=1.948e-11 PD=1.26e-05
+ PS=1.98e-05 NRD=0.566667 NRS=0.6
M10 VDD EN OUT0 VDD P L=8e-07 W=3e-06 AD=9.6e-12 AS=9.9e-12 PD=1.24e-05
+ PS=1.26e-05 NRD=0.366667 NRS=0.533333
M11 OUT1 EN VDD VDD P L=8e-07 W=3e-06 AD=9.9e-12 AS=9.6e-12 PD=1.26e-05
+ PS=1.24e-05 NRD=0.366667 NRS=0.533333
M12 VDD A0 OUT1 VDD P L=8e-07 W=3e-06 AD=9.6e-12 AS=9.9e-12 PD=1.24e-05
+ PS=1.26e-05 NRD=0.366667 NRS=0.566667
M13 OUT1 5 VDD VDD P L=8e-07 W=3e-06 AD=8.7e-12 AS=9.6e-12 PD=1.18e-05
+ PS=1.24e-05 NRD=0.366667 NRS=0.533333
M14 23 A1 OUT3 GROUND N L=8e-07 W=3e-06 AD=1.5e-12 AS=9.3e-12 PD=4e-06
+ PS=1.22e-05 NRD=0.166667 NRS=0.6
M15 24 A0 23 GROUND N L=8e-07 W=3e-06 AD=3.375e-12 AS=1.5e-12 PD=5.25e-06
+ PS=4e-06 NRD=0.375 NRS=0.166667
M16 GROUND EN 24 GROUND N L=8e-07 W=3e-06 AD=9.6e-12 AS=3.375e-12 PD=1.24e-05
+ PS=5.25e-06 NRD=0.533333 NRS=0.375
M17 25 EN GROUND GROUND N L=8e-07 W=3e-06 AD=2.25e-12 AS=9.6e-12 PD=4.5e-06
+ PS=1.24e-05 NRD=0.25 NRS=0.533333
M18 26 7 25 GROUND N L=8e-07 W=3e-06 AD=2.85e-12 AS=2.25e-12 PD=4.9e-06
+ PS=4.5e-06 NRD=0.316667 NRS=0.25
M19 OUT2 A1 26 GROUND N L=8e-07 W=3e-06 AD=8.7e-12 AS=2.85e-12 PD=1.18e-05
+ PS=4.9e-06 NRD=0.533333 NRS=0.316667
M20 5 A1 GROUND GROUND N L=8e-07 W=2e-06 AD=9.56e-12 AS=7.76e-12 PD=1.32e-05
+ PS=1.14e-05 NRD=0.825 NRS=0.9
M21 7 A0 GROUND GROUND N L=8e-07 W=2e-06 AD=7.76e-12 AS=7.76e-12 PD=1.14e-05
+ PS=1.14e-05 NRD=0.6 NRS=0.9
M22 27 5 OUT0 GROUND N L=8e-07 W=3e-06 AD=1.5e-12 AS=8.7e-12 PD=4e-06
+ PS=1.18e-05 NRD=0.166667 NRS=0.533333
M23 28 7 27 GROUND N L=8e-07 W=3e-06 AD=1.5e-12 AS=1.5e-12 PD=4e-06 PS=4e-06
+ NRD=0.166667 NRS=0.166667
M24 GROUND EN 28 GROUND N L=8e-07 W=3e-06 AD=9.6e-12 AS=1.5e-12 PD=1.24e-05
+ PS=4e-06 NRD=0.533333 NRS=0.166667
M25 29 EN GROUND GROUND N L=8e-07 W=3e-06 AD=2.025e-12 AS=9.6e-12 PD=4.35e-06
+ PS=1.24e-05 NRD=0.225 NRS=0.533333
M26 30 A0 29 GROUND N L=8e-07 W=3e-06 AD=4.95e-12 AS=2.025e-12 PD=6.3e-06
+ PS=4.35e-06 NRD=0.55 NRS=0.225
M27 OUT1 5 30 GROUND N L=8e-07 W=3e-06 AD=8.7e-12 AS=4.95e-12 PD=1.18e-05
+ PS=6.3e-06 NRD=0.533333 NRS=0.55
.ends

.subckt DELY00 IN1 OUT1 GROUND VDD
M0 3 IN1 VDD VDD P L=4.6e-06 W=3e-06 AD=9.3e-12 AS=8.7e-12 PD=1.22e-05
+ PS=1.18e-05 NRD=0.4 NRS=0.533333
M1 4 3 VDD VDD P L=4.6e-06 W=3e-06 AD=9.3e-12 AS=8.7e-12 PD=1.22e-05 PS=1.18e-05
+ NRD=0.4 NRS=0.533333
M2 5 4 VDD VDD P L=4.6e-06 W=3e-06 AD=9.3e-12 AS=8.7e-12 PD=1.22e-05 PS=1.18e-05
+ NRD=0.4 NRS=0.533333
M3 6 5 VDD VDD P L=4.6e-06 W=3e-06 AD=9.3e-12 AS=8.7e-12 PD=1.22e-05 PS=1.18e-05
+ NRD=0.4 NRS=0.533333
M4 7 6 VDD VDD P L=4.6e-06 W=3e-06 AD=9.3e-12 AS=8.7e-12 PD=1.22e-05 PS=1.18e-05
+ NRD=0.4 NRS=0.533333
M5 8 7 VDD VDD P L=8e-07 W=3e-06 AD=9.3e-12 AS=8.7e-12 PD=1.22e-05 PS=1.18e-05
+ NRD=0.4 NRS=0.533333
M6 9 8 VDD VDD P L=8e-07 W=3e-06 AD=9.3e-12 AS=8.7e-12 PD=1.22e-05 PS=1.18e-05
+ NRD=0.4 NRS=0.533333
M7 OUT1 9 VDD VDD P L=8e-07 W=3.2e-06 AD=9.92e-12 AS=9.28e-12 PD=1.26e-05
+ PS=1.22e-05 NRD=0.375 NRS=0.5
M8 3 IN1 GROUND GROUND N L=5.9e-06 W=2e-06 AD=7.76e-12 AS=7.76e-12 PD=1.14e-05
+ PS=1.14e-05 NRD=0.6 NRS=0.9
M9 4 3 GROUND GROUND N L=5.9e-06 W=2e-06 AD=7.76e-12 AS=7.76e-12 PD=1.14e-05
+ PS=1.14e-05 NRD=0.6 NRS=0.9
M10 5 4 GROUND GROUND N L=5.9e-06 W=2e-06 AD=7.76e-12 AS=7.76e-12 PD=1.14e-05
+ PS=1.14e-05 NRD=0.6 NRS=0.9
M11 6 5 GROUND GROUND N L=5.9e-06 W=2e-06 AD=7.76e-12 AS=7.76e-12 PD=1.14e-05
+ PS=1.14e-05 NRD=0.6 NRS=0.9
M12 7 6 GROUND GROUND N L=5.9e-06 W=2e-06 AD=7.76e-12 AS=7.76e-12 PD=1.14e-05
+ PS=1.14e-05 NRD=0.6 NRS=0.9
M13 8 7 GROUND GROUND N L=8e-07 W=2e-06 AD=7.76e-12 AS=7.76e-12 PD=1.14e-05
+ PS=1.14e-05 NRD=0.6 NRS=0.9
M14 9 8 GROUND GROUND N L=8e-07 W=2e-06 AD=7.76e-12 AS=7.76e-12 PD=1.14e-05
+ PS=1.14e-05 NRD=0.6 NRS=0.9
M15 OUT1 9 GROUND GROUND N L=8e-07 W=2e-06 AD=7.76e-12 AS=7.76e-12 PD=1.14e-05
+ PS=1.14e-05 NRD=0.6 NRS=0.9
.ends

.subckt DFCL11 C D CLR QB Q GROUND VDD
M0 VDD C 11 VDD P L=8e-07 W=3e-06 AD=9.6e-12 AS=8.7e-12 PD=1.24e-05 PS=1.18e-05
+ NRD=0.366667 NRS=0.533333
M1 12 11 VDD VDD P L=8e-07 W=3e-06 AD=8.7e-12 AS=9.6e-12 PD=1.18e-05 PS=1.24e-05
+ NRD=0.366667 NRS=0.533333
M2 3 12 D VDD P L=8e-07 W=3e-06 AD=1.05e-11 AS=8.7e-12 PD=1.3e-05 PS=1.18e-05
+ NRD=0.391667 NRS=0.533333
M3 4 11 3 VDD P L=8e-07 W=3e-06 AD=1.08e-11 AS=1.05e-11 PD=1.32e-05 PS=1.3e-05
+ NRD=0.408333 NRS=0.583333
M4 VDD 6 4 VDD P L=8e-07 W=3e-06 AD=8.7e-12 AS=1.08e-11 PD=1.18e-05 PS=1.32e-05
+ NRD=0.366667 NRS=0.583333
M5 VDD CLR 6 VDD P L=8e-07 W=3e-06 AD=9.6e-12 AS=8.7e-12 PD=1.24e-05 PS=1.18e-05
+ NRD=0.366667 NRS=0.533333
M6 6 3 VDD VDD P L=8e-07 W=3e-06 AD=1.08e-11 AS=9.6e-12 PD=1.32e-05 PS=1.24e-05
+ NRD=0.391667 NRS=0.533333
M7 7 11 6 VDD P L=8e-07 W=3e-06 AD=1.08e-11 AS=1.08e-11 PD=1.32e-05 PS=1.32e-05
+ NRD=0.391667 NRS=0.616667
M8 8 12 7 VDD P L=8e-07 W=3e-06 AD=1.05e-11 AS=1.08e-11 PD=1.3e-05 PS=1.32e-05
+ NRD=0.391667 NRS=0.616667
M9 VDD 13 8 VDD P L=8e-07 W=3e-06 AD=9.6e-12 AS=1.05e-11 PD=1.24e-05 PS=1.3e-05
+ NRD=0.366667 NRS=0.583333
M10 8 CLR VDD VDD P L=8e-07 W=3e-06 AD=8.7e-12 AS=9.6e-12 PD=1.18e-05
+ PS=1.24e-05 NRD=0.366667 NRS=0.533333
M11 13 7 VDD VDD P L=8e-07 W=3e-06 AD=8.7e-12 AS=8.7e-12 PD=1.18e-05 PS=1.18e-05
+ NRD=0.366667 NRS=0.533333
M12 VDD 13 QB VDD P L=8e-07 W=4.4e-06 AD=1.441e-11 AS=1.276e-11 PD=1.56e-05
+ PS=1.46e-05 NRD=0.25 NRS=0.363636
M13 Q QB VDD VDD P L=8e-07 W=4.6e-06 AD=1.334e-11 AS=1.441e-11 PD=1.5e-05
+ PS=1.56e-05 NRD=0.23913 NRS=0.347826
M14 GROUND C 11 GROUND N L=8e-07 W=2e-06 AD=8.24e-12 AS=7.5e-12 PD=1.2e-05
+ PS=1.12e-05 NRD=0.575 NRS=0.85
M15 12 11 GROUND GROUND N L=8e-07 W=2e-06 AD=7.5e-12 AS=8.24e-12 PD=1.12e-05
+ PS=1.2e-05 NRD=0.575 NRS=0.85
M16 3 11 D GROUND N L=8e-07 W=2e-06 AD=8.76e-12 AS=7.5e-12 PD=1.24e-05
+ PS=1.12e-05 NRD=0.6 NRS=0.85
M17 4 12 3 GROUND N L=8e-07 W=2e-06 AD=3.056e-11 AS=8.76e-12 PD=2.34e-05
+ PS=1.24e-05 NRD=0.9 NRS=0.9
M18 GROUND 6 4 GROUND N L=8e-07 W=2e-06 AD=2.236e-11 AS=3.056e-11 PD=2.42e-05
+ PS=2.34e-05 NRD=0.9 NRS=0.9
M19 29 CLR GROUND GROUND N L=8e-07 W=2e-06 AD=3.2e-12 AS=2.236e-11 PD=5.2e-06
+ PS=2.42e-05 NRD=0.8 NRS=0.9
M20 6 3 29 GROUND N L=8e-07 W=2e-06 AD=8.76e-12 AS=3.2e-12 PD=1.24e-05
+ PS=5.2e-06 NRD=0.9 NRS=0.8
M21 7 12 6 GROUND N L=8e-07 W=2e-06 AD=8.76e-12 AS=8.76e-12 PD=1.24e-05
+ PS=1.24e-05 NRD=0.6 NRS=0.9
M22 8 11 7 GROUND N L=8e-07 W=2e-06 AD=2.92e-11 AS=8.76e-12 PD=2.3e-05
+ PS=1.24e-05 NRD=0.9 NRS=0.9
M23 30 13 8 GROUND N L=8e-07 W=2e-06 AD=4.6e-12 AS=2.92e-11 PD=6.6e-06
+ PS=2.3e-05 NRD=1.15 NRS=0.9
M24 GROUND CLR 30 GROUND N L=8e-07 W=2e-06 AD=1.962e-11 AS=4.6e-12 PD=2.14e-05
+ PS=6.6e-06 NRD=0.9 NRS=1.15
M25 13 7 GROUND GROUND N L=8e-07 W=2e-06 AD=7.76e-12 AS=1.962e-11 PD=1.14e-05
+ PS=2.14e-05 NRD=0.9 NRS=0.9
M26 GROUND 13 QB GROUND N L=8e-07 W=2.4e-06 AD=9.16e-12 AS=7.96e-12 PD=1.24e-05
+ PS=1.14e-05 NRD=0.5 NRS=0.75
M27 Q QB GROUND GROUND N L=8e-07 W=2.4e-06 AD=7.96e-12 AS=9.16e-12 PD=1.14e-05
+ PS=1.24e-05 NRD=0.5 NRS=0.75
.ends

.subckt DFFL11 C D QB Q GROUND VDD
M0 VDD C 10 VDD P L=8e-07 W=3e-06 AD=9.6e-12 AS=8.7e-12 PD=1.24e-05 PS=1.18e-05
+ NRD=0.366667 NRS=0.533333
M1 11 10 VDD VDD P L=8e-07 W=3e-06 AD=8.7e-12 AS=9.6e-12 PD=1.18e-05 PS=1.24e-05
+ NRD=0.366667 NRS=0.533333
M2 3 11 D VDD P L=8e-07 W=3e-06 AD=1.05e-11 AS=8.7e-12 PD=1.3e-05 PS=1.18e-05
+ NRD=0.391667 NRS=0.533333
M3 4 10 3 VDD P L=8e-07 W=3e-06 AD=1.08e-11 AS=1.05e-11 PD=1.32e-05 PS=1.3e-05
+ NRD=0.408333 NRS=0.583333
M4 VDD 5 4 VDD P L=8e-07 W=3e-06 AD=8.7e-12 AS=1.08e-11 PD=1.18e-05 PS=1.32e-05
+ NRD=0.366667 NRS=0.583333
M5 5 3 VDD VDD P L=8e-07 W=3e-06 AD=1.08e-11 AS=8.7e-12 PD=1.32e-05 PS=1.18e-05
+ NRD=0.391667 NRS=0.533333
M6 6 10 5 VDD P L=8e-07 W=3e-06 AD=1.08e-11 AS=1.08e-11 PD=1.32e-05 PS=1.32e-05
+ NRD=0.391667 NRS=0.616667
M7 QB 11 6 VDD P L=8e-07 W=3e-06 AD=1.59e-11 AS=1.08e-11 PD=1.66e-05 PS=1.32e-05
+ NRD=0.391667 NRS=0.616667
M8 VDD Q QB VDD P L=8e-07 W=4.8e-06 AD=1.392e-11 AS=1.59e-11 PD=1.54e-05
+ PS=1.66e-05 NRD=0.229167 NRS=0.364583
M9 Q 6 VDD VDD P L=8e-07 W=4.7e-06 AD=1.483e-11 AS=1.483e-11 PD=1.58e-05
+ PS=1.58e-05 NRD=0.297872 NRS=0.382979
M10 GROUND C 10 GROUND N L=8e-07 W=2e-06 AD=8.24e-12 AS=7.5e-12 PD=1.2e-05
+ PS=1.12e-05 NRD=0.575 NRS=0.85
M11 11 10 GROUND GROUND N L=8e-07 W=2e-06 AD=7.5e-12 AS=8.24e-12 PD=1.12e-05
+ PS=1.2e-05 NRD=0.575 NRS=0.85
M12 3 10 D GROUND N L=8e-07 W=2e-06 AD=8.76e-12 AS=7.5e-12 PD=1.24e-05
+ PS=1.12e-05 NRD=0.6 NRS=0.85
M13 4 11 3 GROUND N L=8e-07 W=2e-06 AD=3.056e-11 AS=8.76e-12 PD=2.34e-05
+ PS=1.24e-05 NRD=0.9 NRS=0.9
M14 GROUND 5 4 GROUND N L=8e-07 W=2e-06 AD=1.876e-11 AS=3.056e-11 PD=2.06e-05
+ PS=2.34e-05 NRD=0.9 NRS=0.9
M15 5 3 GROUND GROUND N L=8e-07 W=2e-06 AD=8.76e-12 AS=1.876e-11 PD=1.24e-05
+ PS=2.06e-05 NRD=0.9 NRS=0.9
M16 6 11 5 GROUND N L=8e-07 W=2e-06 AD=8.76e-12 AS=8.76e-12 PD=1.24e-05
+ PS=1.24e-05 NRD=0.6 NRS=0.9
M17 QB 10 6 GROUND N L=8e-07 W=2e-06 AD=3.2e-11 AS=8.76e-12 PD=2.4e-05
+ PS=1.24e-05 NRD=0.9 NRS=0.9
M18 GROUND Q QB GROUND N L=8e-07 W=2.5e-06 AD=2.082e-11 AS=3.2e-11 PD=2.14e-05
+ PS=2.4e-05 NRD=0.72 NRS=0.72
M19 Q 6 GROUND GROUND N L=8e-07 W=2.5e-06 AD=9.31e-12 AS=2.082e-11 PD=1.24e-05
+ PS=2.14e-05 NRD=0.72 NRS=0.72
.ends

.subckt DFPC11 C D PRB CLR QB Q GROUND VDD
M0 VDD C 12 VDD P L=8e-07 W=3e-06 AD=9.6e-12 AS=8.7e-12 PD=1.24e-05 PS=1.18e-05
+ NRD=0.366667 NRS=0.533333
M1 13 12 VDD VDD P L=8e-07 W=3e-06 AD=8.7e-12 AS=9.6e-12 PD=1.18e-05 PS=1.24e-05
+ NRD=0.366667 NRS=0.533333
M2 3 13 D VDD P L=8e-07 W=3e-06 AD=1.05e-11 AS=8.7e-12 PD=1.3e-05 PS=1.18e-05
+ NRD=0.391667 NRS=0.533333
M3 4 12 3 VDD P L=8e-07 W=3e-06 AD=1.111e-11 AS=1.05e-11 PD=1.34e-05 PS=1.3e-05
+ NRD=0.408333 NRS=0.583333
M4 VDD 7 4 VDD P L=8e-07 W=3.1e-06 AD=9.92e-12 AS=1.111e-11 PD=1.26e-05
+ PS=1.34e-05 NRD=0.354839 NRS=0.564516
M5 4 PRB VDD VDD P L=8e-07 W=3.1e-06 AD=8.99e-12 AS=9.92e-12 PD=1.2e-05
+ PS=1.26e-05 NRD=0.354839 NRS=0.516129
M6 VDD CLR 7 VDD P L=8e-07 W=3.1e-06 AD=9.92e-12 AS=1.24e-11 PD=1.26e-05
+ PS=1.42e-05 NRD=0.354839 NRS=0.870968
M7 7 3 VDD VDD P L=8e-07 W=3.1e-06 AD=1.11e-11 AS=9.92e-12 PD=1.34e-05
+ PS=1.26e-05 NRD=0.379032 NRS=0.516129
M8 8 12 7 VDD P L=8e-07 W=3e-06 AD=1.08e-11 AS=1.11e-11 PD=1.32e-05 PS=1.34e-05
+ NRD=0.391667 NRS=0.616667
M9 9 13 8 VDD P L=8e-07 W=3e-06 AD=1.08e-11 AS=1.08e-11 PD=1.32e-05 PS=1.32e-05
+ NRD=0.391667 NRS=0.616667
M10 VDD 14 9 VDD P L=8e-07 W=3.1e-06 AD=9.92e-12 AS=1.08e-11 PD=1.26e-05
+ PS=1.32e-05 NRD=0.354839 NRS=0.564516
M11 9 CLR VDD VDD P L=8e-07 W=3.1e-06 AD=8.99e-12 AS=9.92e-12 PD=1.2e-05
+ PS=1.26e-05 NRD=0.354839 NRS=0.516129
M12 VDD PRB 14 VDD P L=8e-07 W=3.1e-06 AD=9.92e-12 AS=8.99e-12 PD=1.26e-05
+ PS=1.2e-05 NRD=0.354839 NRS=0.516129
M13 14 8 VDD VDD P L=8e-07 W=3.1e-06 AD=8.99e-12 AS=9.92e-12 PD=1.2e-05
+ PS=1.26e-05 NRD=0.354839 NRS=0.516129
M14 VDD 14 QB VDD P L=8e-07 W=4.5e-06 AD=1.44e-11 AS=1.305e-11 PD=1.54e-05
+ PS=1.48e-05 NRD=0.244444 NRS=0.355556
M15 Q QB VDD VDD P L=8e-07 W=4.5e-06 AD=1.305e-11 AS=1.44e-11 PD=1.48e-05
+ PS=1.54e-05 NRD=0.244444 NRS=0.355556
M16 GROUND C 12 GROUND N L=8e-07 W=2e-06 AD=8.24e-12 AS=7.5e-12 PD=1.2e-05
+ PS=1.12e-05 NRD=0.575 NRS=0.85
M17 13 12 GROUND GROUND N L=8e-07 W=2e-06 AD=7.5e-12 AS=8.24e-12 PD=1.12e-05
+ PS=1.2e-05 NRD=0.575 NRS=0.85
M18 3 12 D GROUND N L=8e-07 W=2e-06 AD=8.76e-12 AS=7.5e-12 PD=1.24e-05
+ PS=1.12e-05 NRD=0.6 NRS=0.85
M19 4 13 3 GROUND N L=8e-07 W=2e-06 AD=3.076e-11 AS=8.76e-12 PD=2.34e-05
+ PS=1.24e-05 NRD=0.9 NRS=0.9
M20 32 7 4 GROUND N L=8e-07 W=2.4e-06 AD=2.88e-12 AS=3.076e-11 PD=4.8e-06
+ PS=2.34e-05 NRD=0.5 NRS=0.75
M21 GROUND PRB 32 GROUND N L=8e-07 W=2.4e-06 AD=2.996e-11 AS=2.88e-12
+ PD=2.92e-05 PS=4.8e-06 NRD=0.75 NRS=0.5
M22 33 CLR GROUND GROUND N L=8e-07 W=2.4e-06 AD=3.84e-12 AS=2.996e-11 PD=5.6e-06
+ PS=2.92e-05 NRD=0.666667 NRS=0.75
M23 7 3 33 GROUND N L=8e-07 W=2.4e-06 AD=8.96e-12 AS=3.84e-12 PD=1.24e-05
+ PS=5.6e-06 NRD=0.75 NRS=0.666667
M24 8 13 7 GROUND N L=8e-07 W=2e-06 AD=8.76e-12 AS=8.96e-12 PD=1.24e-05
+ PS=1.24e-05 NRD=0.6 NRS=0.9
M25 9 12 8 GROUND N L=8e-07 W=2e-06 AD=2.944e-11 AS=8.76e-12 PD=2.3e-05
+ PS=1.24e-05 NRD=0.9 NRS=0.9
M26 34 14 9 GROUND N L=8e-07 W=2.4e-06 AD=5.52e-12 AS=2.944e-11 PD=7e-06
+ PS=2.3e-05 NRD=0.958333 NRS=0.75
M27 GROUND CLR 34 GROUND N L=8e-07 W=2.4e-06 AD=1.826e-11 AS=5.52e-12
+ PD=1.94e-05 PS=7e-06 NRD=0.75 NRS=0.958333
M28 35 PRB GROUND GROUND N L=8e-07 W=2.4e-06 AD=4.8e-12 AS=1.826e-11 PD=6.4e-06
+ PS=1.94e-05 NRD=0.833333 NRS=0.75
M29 14 8 35 GROUND N L=8e-07 W=2.4e-06 AD=7.96e-12 AS=4.8e-12 PD=1.14e-05
+ PS=6.4e-06 NRD=0.75 NRS=0.833333
M30 GROUND 14 QB GROUND N L=8e-07 W=2.5e-06 AD=9.26e-12 AS=8.01e-12 PD=1.24e-05
+ PS=1.14e-05 NRD=0.48 NRS=0.72
M31 Q QB GROUND GROUND N L=8e-07 W=2.5e-06 AD=8.01e-12 AS=9.26e-12 PD=1.14e-05
+ PS=1.24e-05 NRD=0.48 NRS=0.72
.ends

.subckt DFPR11 C D PRB QB Q GROUND VDD
M0 VDD C 11 VDD P L=8e-07 W=3.3e-06 AD=1.04e-11 AS=9.57e-12 PD=1.3e-05
+ PS=1.24e-05 NRD=0.333333 NRS=0.484848
M1 12 11 VDD VDD P L=8e-07 W=3.2e-06 AD=9.28e-12 AS=1.04e-11 PD=1.22e-05
+ PS=1.3e-05 NRD=0.34375 NRS=0.5
M2 3 12 D VDD P L=8e-07 W=4e-06 AD=1.35e-11 AS=1.16e-11 PD=1.5e-05 PS=1.38e-05
+ NRD=0.29375 NRS=0.4
M3 4 11 3 VDD P L=8e-07 W=3e-06 AD=1.111e-11 AS=1.35e-11 PD=1.34e-05 PS=1.5e-05
+ NRD=0.408333 NRS=0.583333
M4 VDD 6 4 VDD P L=8e-07 W=3.1e-06 AD=9.92e-12 AS=1.111e-11 PD=1.26e-05
+ PS=1.34e-05 NRD=0.354839 NRS=0.564516
M5 4 PRB VDD VDD P L=8e-07 W=3.1e-06 AD=8.99e-12 AS=9.92e-12 PD=1.2e-05
+ PS=1.26e-05 NRD=0.354839 NRS=0.516129
M6 6 3 VDD VDD P L=8e-07 W=3e-06 AD=1.08e-11 AS=8.7e-12 PD=1.32e-05 PS=1.18e-05
+ NRD=0.391667 NRS=0.533333
M7 7 11 6 VDD P L=8e-07 W=3e-06 AD=1.08e-11 AS=1.08e-11 PD=1.32e-05 PS=1.32e-05
+ NRD=0.391667 NRS=0.616667
M8 8 12 7 VDD P L=8e-07 W=3e-06 AD=1.05e-11 AS=1.08e-11 PD=1.3e-05 PS=1.32e-05
+ NRD=0.391667 NRS=0.616667
M9 VDD 13 8 VDD P L=8e-07 W=3e-06 AD=8.7e-12 AS=1.05e-11 PD=1.18e-05 PS=1.3e-05
+ NRD=0.366667 NRS=0.583333
M10 VDD PRB 13 VDD P L=8e-07 W=3.1e-06 AD=9.92e-12 AS=8.99e-12 PD=1.26e-05
+ PS=1.2e-05 NRD=0.354839 NRS=0.516129
M11 13 7 VDD VDD P L=8e-07 W=3.1e-06 AD=8.99e-12 AS=9.92e-12 PD=1.2e-05
+ PS=1.26e-05 NRD=0.354839 NRS=0.516129
M12 VDD 13 QB VDD P L=8e-07 W=4.4e-06 AD=1.434e-11 AS=1.276e-11 PD=1.54e-05
+ PS=1.46e-05 NRD=0.25 NRS=0.363636
M13 Q QB VDD VDD P L=8e-07 W=4.5e-06 AD=1.305e-11 AS=1.434e-11 PD=1.48e-05
+ PS=1.54e-05 NRD=0.244444 NRS=0.355556
M14 GROUND C 11 GROUND N L=8e-07 W=2e-06 AD=8.24e-12 AS=7.5e-12 PD=1.2e-05
+ PS=1.12e-05 NRD=0.575 NRS=0.85
M15 12 11 GROUND GROUND N L=8e-07 W=2e-06 AD=7.5e-12 AS=8.24e-12 PD=1.12e-05
+ PS=1.2e-05 NRD=0.575 NRS=0.85
M16 3 11 D GROUND N L=8e-07 W=2e-06 AD=8.76e-12 AS=7.5e-12 PD=1.24e-05
+ PS=1.12e-05 NRD=0.6 NRS=0.85
M17 4 12 3 GROUND N L=8e-07 W=2e-06 AD=3.076e-11 AS=8.76e-12 PD=2.34e-05
+ PS=1.24e-05 NRD=0.9 NRS=0.9
M18 29 6 4 GROUND N L=8e-07 W=2.4e-06 AD=2.88e-12 AS=3.076e-11 PD=4.8e-06
+ PS=2.34e-05 NRD=0.5 NRS=0.75
M19 GROUND PRB 29 GROUND N L=8e-07 W=2.4e-06 AD=2.794e-11 AS=2.88e-12
+ PD=2.76e-05 PS=4.8e-06 NRD=0.75 NRS=0.5
M20 6 3 GROUND GROUND N L=8e-07 W=2.2e-06 AD=8.86e-12 AS=2.794e-11 PD=1.24e-05
+ PS=2.76e-05 NRD=0.818182 NRS=0.818182
M21 7 12 6 GROUND N L=8e-07 W=2e-06 AD=8.76e-12 AS=8.86e-12 PD=1.24e-05
+ PS=1.24e-05 NRD=0.6 NRS=0.9
M22 8 11 7 GROUND N L=8e-07 W=2e-06 AD=2.77e-11 AS=8.76e-12 PD=2.24e-05
+ PS=1.24e-05 NRD=0.9 NRS=0.9
M23 GROUND 13 8 GROUND N L=8e-07 W=2e-06 AD=1.806e-11 AS=2.77e-11 PD=1.94e-05
+ PS=2.24e-05 NRD=0.9 NRS=0.9
M24 30 PRB GROUND GROUND N L=8e-07 W=2.4e-06 AD=4.8e-12 AS=1.806e-11 PD=6.4e-06
+ PS=1.94e-05 NRD=0.833333 NRS=0.75
M25 13 7 30 GROUND N L=8e-07 W=2.4e-06 AD=7.96e-12 AS=4.8e-12 PD=1.14e-05
+ PS=6.4e-06 NRD=0.75 NRS=0.833333
M26 GROUND 13 QB GROUND N L=8e-07 W=2.4e-06 AD=9.16e-12 AS=7.96e-12 PD=1.24e-05
+ PS=1.14e-05 NRD=0.5 NRS=0.75
M27 Q QB GROUND GROUND N L=8e-07 W=2.4e-06 AD=7.96e-12 AS=9.16e-12 PD=1.14e-05
+ PS=1.24e-05 NRD=0.5 NRS=0.75
.ends

.subckt INVR00 IN1 OUT1 GROUND VDD
M0 OUT1 IN1 VDD VDD P L=8e-07 W=3e-06 AD=9.3e-12 AS=8.7e-12 PD=1.22e-05
+ PS=1.18e-05 NRD=0.4 NRS=0.533333
M1 OUT1 IN1 GROUND GROUND N L=8e-07 W=2e-06 AD=7.76e-12 AS=7.76e-12 PD=1.14e-05
+ PS=1.14e-05 NRD=0.6 NRS=0.9
.ends

.subckt INVR01 IN1 OUT1 GROUND VDD
M0 OUT1 IN1 VDD VDD P L=8e-07 W=4.5e-06 AD=1.473e-11 AS=1.473e-11 PD=1.58e-05
+ PS=1.58e-05 NRD=0.311111 NRS=0.4
M1 OUT1 IN1 GROUND GROUND N L=8e-07 W=2.5e-06 AD=8.79e-12 AS=7.99e-12 PD=1.2e-05
+ PS=1.14e-05 NRD=0.48 NRS=0.72
.ends

.subckt INVR02 IN1 OUT1 GROUND VDD
M0 OUT1 IN1 VDD VDD P L=8e-07 W=6e-06 AD=1.74e-11 AS=1.74e-11 PD=1.78e-05
+ PS=1.78e-05 NRD=0.211111 NRS=0.266667
M1 OUT1 IN1 GROUND GROUND N L=8e-07 W=3e-06 AD=8.7e-12 AS=8.7e-12 PD=1.18e-05
+ PS=1.18e-05 NRD=0.366667 NRS=0.533333
.ends

.subckt INVR03 IN1 OUT1 GROUND VDD
M0 OUT1 IN1 VDD VDD P L=8e-07 W=4e-06 AD=1.28e-11 AS=1.18e-11 PD=1.44e-05
+ PS=1.39e-05 NRD=0.275 NRS=0.4
M1 VDD IN1 OUT1 VDD P L=8e-07 W=4e-06 AD=1.18e-11 AS=1.28e-11 PD=1.39e-05
+ PS=1.44e-05 NRD=0.28125 NRS=0.4
M2 OUT1 IN1 GROUND GROUND N L=8e-07 W=3.6e-06 AD=1.044e-11 AS=1.278e-11
+ PD=1.3e-05 PS=1.43e-05 NRD=0.305556 NRS=0.5
.ends

.subckt INVR04 IN1 OUT1 GROUND VDD
M0 OUT1 IN1 VDD VDD P L=8e-07 W=4.6e-06 AD=1.472e-11 AS=1.478e-11 PD=1.56e-05
+ PS=1.58e-05 NRD=0.23913 NRS=0.391304
M1 VDD IN1 OUT1 VDD P L=8e-07 W=4.6e-06 AD=1.478e-11 AS=1.472e-11 PD=1.58e-05
+ PS=1.56e-05 NRD=0.304348 NRS=0.347826
M2 OUT1 IN1 GROUND GROUND N L=8e-07 W=4e-06 AD=1.16e-11 AS=1.42e-11 PD=1.38e-05
+ PS=1.51e-05 NRD=0.275 NRS=0.45
.ends

.subckt INVR05 IN1 OUT1 GROUND VDD
M0 OUT1 IN1 VDD VDD P L=8e-07 W=5.7e-06 AD=2.26e-11 AS=1.819e-11 PD=2.02e-05
+ PS=1.8e-05 NRD=0.216374 NRS=0.315789
M1 VDD IN1 OUT1 VDD P L=8e-07 W=5.7e-06 AD=1.819e-11 AS=2.26e-11 PD=1.8e-05
+ PS=2.02e-05 NRD=0.298246 NRS=0.24812
M2 OUT1 IN1 GROUND GROUND N L=8e-07 W=4.7e-06 AD=1.483e-11 AS=1.84e-11
+ PD=1.58e-05 PS=1.73e-05 NRD=0.255319 NRS=0.446809
.ends

.subckt LTCH11 C D Q QB GROUND VDD
M0 VDD C 5 VDD P L=8e-07 W=3e-06 AD=9.6e-12 AS=8.7e-12 PD=1.24e-05 PS=1.18e-05
+ NRD=0.366667 NRS=0.533333
M1 6 5 VDD VDD P L=8e-07 W=3e-06 AD=8.7e-12 AS=9.6e-12 PD=1.18e-05 PS=1.24e-05
+ NRD=0.366667 NRS=0.533333
M2 7 5 D VDD P L=8e-07 W=3e-06 AD=1.05e-11 AS=8.7e-12 PD=1.3e-05 PS=1.18e-05
+ NRD=0.416667 NRS=0.533333
M3 Q 6 7 VDD P L=8e-07 W=3e-06 AD=8.7e-12 AS=1.05e-11 PD=1.18e-05 PS=1.3e-05
+ NRD=0.366667 NRS=0.533333
M4 VDD 7 QB VDD P L=8e-07 W=4.9e-06 AD=1.754e-11 AS=1.519e-11 PD=1.7e-05
+ PS=1.6e-05 NRD=0.285714 NRS=0.367347
M5 Q QB VDD VDD P L=8e-07 W=4.7e-06 AD=1.483e-11 AS=1.754e-11 PD=1.58e-05
+ PS=1.7e-05 NRD=0.297872 NRS=0.382979
M6 GROUND C 5 GROUND N L=8e-07 W=2e-06 AD=1.589e-11 AS=7.76e-12 PD=1.95e-05
+ PS=1.14e-05 NRD=0.9 NRS=0.9
M7 6 5 GROUND GROUND N L=8e-07 W=2e-06 AD=7.73e-12 AS=1.589e-11 PD=1.14e-05
+ PS=1.95e-05 NRD=0.9 NRS=0.9
M8 7 6 D GROUND N L=8e-07 W=2e-06 AD=8.76e-12 AS=7.5e-12 PD=1.24e-05 PS=1.12e-05
+ NRD=0.6 NRS=0.85
M9 Q 5 7 GROUND N L=8e-07 W=2e-06 AD=8.02e-12 AS=8.76e-12 PD=1.16e-05
+ PS=1.24e-05 NRD=0.625 NRS=0.9
M10 GROUND 7 QB GROUND N L=8e-07 W=2.7e-06 AD=9.62e-12 AS=8.37e-12 PD=1.26e-05
+ PS=1.16e-05 NRD=0.444444 NRS=0.666667
M11 Q QB GROUND GROUND N L=8e-07 W=2.5e-06 AD=8.01e-12 AS=9.62e-12 PD=1.14e-05
+ PS=1.26e-05 NRD=0.48 NRS=0.72
.ends

.subckt LTCL11 C D CLR Q QB GROUND VDD
M0 VDD C 7 VDD P L=8e-07 W=3e-06 AD=9.6e-12 AS=8.7e-12 PD=1.24e-05 PS=1.18e-05
+ NRD=0.366667 NRS=0.533333
M1 8 7 VDD VDD P L=8e-07 W=3e-06 AD=8.7e-12 AS=9.6e-12 PD=1.18e-05 PS=1.24e-05
+ NRD=0.366667 NRS=0.533333
M2 9 7 D VDD P L=8e-07 W=3e-06 AD=1.05e-11 AS=8.7e-12 PD=1.3e-05 PS=1.18e-05
+ NRD=0.416667 NRS=0.533333
M3 10 8 9 VDD P L=8e-07 W=3e-06 AD=8.7e-12 AS=1.05e-11 PD=1.18e-05 PS=1.3e-05
+ NRD=0.366667 NRS=0.533333
M4 3 9 VDD VDD P L=8e-07 W=3.1e-06 AD=1.8755e-11 AS=8.99e-12 PD=1.83e-05
+ PS=1.2e-05 NRD=0.354839 NRS=0.516129
M5 VDD CLR 3 VDD P L=8e-07 W=3.1e-06 AD=2.087e-11 AS=1.8755e-11 PD=1.97e-05
+ PS=1.83e-05 NRD=0.483871 NRS=0.725806
M6 10 3 VDD VDD P L=8e-07 W=3e-06 AD=8.7e-12 AS=2.087e-11 PD=1.18e-05
+ PS=1.97e-05 NRD=0.366667 NRS=0.716667
M7 VDD 3 Q VDD P L=8e-07 W=4.5e-06 AD=1.698e-11 AS=1.473e-11 PD=1.68e-05
+ PS=1.58e-05 NRD=0.311111 NRS=0.4
M8 QB Q VDD VDD P L=8e-07 W=4.5e-06 AD=1.473e-11 AS=1.698e-11 PD=1.58e-05
+ PS=1.68e-05 NRD=0.311111 NRS=0.4
M9 GROUND C 7 GROUND N L=8e-07 W=2e-06 AD=1.589e-11 AS=7.76e-12 PD=1.95e-05
+ PS=1.14e-05 NRD=0.9 NRS=0.9
M10 8 7 GROUND GROUND N L=8e-07 W=2e-06 AD=7.73e-12 AS=1.589e-11 PD=1.14e-05
+ PS=1.95e-05 NRD=0.9 NRS=0.9
M11 9 8 D GROUND N L=8e-07 W=2e-06 AD=8.76e-12 AS=7.5e-12 PD=1.24e-05
+ PS=1.12e-05 NRD=0.6 NRS=0.85
M12 10 7 9 GROUND N L=8e-07 W=2e-06 AD=8.02e-12 AS=8.76e-12 PD=1.16e-05
+ PS=1.24e-05 NRD=0.625 NRS=0.9
M13 20 9 3 GROUND N L=8e-07 W=2.4e-06 AD=6.36e-12 AS=9e-12 PD=7.7e-06
+ PS=1.22e-05 NRD=1.10417 NRS=0.75
M14 GROUND CLR 20 GROUND N L=8e-07 W=2.4e-06 AD=1.85e-11 AS=6.36e-12 PD=1.95e-05
+ PS=7.7e-06 NRD=0.75 NRS=1.10417
M15 10 3 GROUND GROUND N L=8e-07 W=2e-06 AD=1.156e-11 AS=1.85e-11 PD=1.52e-05
+ PS=1.95e-05 NRD=1.85 NRS=0.478723
M16 GROUND 3 Q GROUND N L=8e-07 W=2.5e-06 AD=9.26e-12 AS=8.01e-12 PD=1.24e-05
+ PS=1.14e-05 NRD=0.48 NRS=0.72
M17 QB Q GROUND GROUND N L=8e-07 W=2.5e-06 AD=8.01e-12 AS=9.26e-12 PD=1.14e-05
+ PS=1.24e-05 NRD=0.48 NRS=0.72
.ends

.subckt LTPC11 C D CLR PRB QB Q GROUND VDD
M0 VDD C 8 VDD P L=8e-07 W=3e-06 AD=9.6e-12 AS=8.7e-12 PD=1.24e-05 PS=1.18e-05
+ NRD=0.366667 NRS=0.533333
M1 9 8 VDD VDD P L=8e-07 W=3e-06 AD=8.7e-12 AS=9.6e-12 PD=1.18e-05 PS=1.24e-05
+ NRD=0.366667 NRS=0.533333
M2 10 8 D VDD P L=8e-07 W=3e-06 AD=1.05e-11 AS=8.7e-12 PD=1.3e-05 PS=1.18e-05
+ NRD=0.416667 NRS=0.533333
M3 11 9 10 VDD P L=8e-07 W=3e-06 AD=8.7e-12 AS=1.05e-11 PD=1.18e-05 PS=1.3e-05
+ NRD=0.366667 NRS=0.533333
M4 3 10 VDD VDD P L=8e-07 W=3.1e-06 AD=1.8755e-11 AS=8.99e-12 PD=1.83e-05
+ PS=1.2e-05 NRD=0.354839 NRS=0.516129
M5 VDD CLR 3 VDD P L=8e-07 W=3.1e-06 AD=2.2845e-11 AS=1.8755e-11 PD=2.05e-05
+ PS=1.83e-05 NRD=0.483871 NRS=0.725806
M6 11 PRB VDD VDD P L=8e-07 W=3.1e-06 AD=9.92e-12 AS=2.2845e-11 PD=1.26e-05
+ PS=2.05e-05 NRD=0.354839 NRS=0.693548
M7 VDD 3 11 VDD P L=8e-07 W=3.1e-06 AD=8.99e-12 AS=9.92e-12 PD=1.2e-05
+ PS=1.26e-05 NRD=0.354839 NRS=0.516129
M8 VDD 11 QB VDD P L=8e-07 W=4.9e-06 AD=1.764e-11 AS=1.519e-11 PD=1.7e-05
+ PS=1.6e-05 NRD=0.312925 NRS=0.367347
M9 Q QB VDD VDD P L=8e-07 W=4.9e-06 AD=1.421e-11 AS=1.764e-11 PD=1.56e-05
+ PS=1.7e-05 NRD=0.258503 NRS=0.326531
M10 GROUND C 8 GROUND N L=8e-07 W=2e-06 AD=1.589e-11 AS=7.76e-12 PD=1.95e-05
+ PS=1.14e-05 NRD=0.9 NRS=0.9
M11 9 8 GROUND GROUND N L=8e-07 W=2e-06 AD=7.73e-12 AS=1.589e-11 PD=1.14e-05
+ PS=1.95e-05 NRD=0.9 NRS=0.9
M12 10 9 D GROUND N L=8e-07 W=2e-06 AD=8.76e-12 AS=7.5e-12 PD=1.24e-05
+ PS=1.12e-05 NRD=0.6 NRS=0.85
M13 11 8 10 GROUND N L=8e-07 W=2e-06 AD=8.02e-12 AS=8.76e-12 PD=1.16e-05
+ PS=1.24e-05 NRD=0.625 NRS=0.9
M14 23 10 3 GROUND N L=8e-07 W=2.4e-06 AD=6.36e-12 AS=1.316e-11 PD=7.7e-06
+ PS=1.54e-05 NRD=1.10417 NRS=0.75
M15 GROUND CLR 23 GROUND N L=8e-07 W=2.4e-06 AD=2.604e-11 AS=6.36e-12
+ PD=2.24e-05 PS=7.7e-06 NRD=0.75 NRS=1.10417
M16 24 PRB GROUND GROUND N L=8e-07 W=2.4e-06 AD=1.8e-12 AS=2.604e-11 PD=3.9e-06
+ PS=2.24e-05 NRD=0.3125 NRS=0.75
M17 11 3 24 GROUND N L=8e-07 W=2.4e-06 AD=2.42e-11 AS=1.8e-12 PD=2.46e-05
+ PS=3.9e-06 NRD=0.75 NRS=0.3125
M18 GROUND 11 QB GROUND N L=8e-07 W=2.5e-06 AD=9.26e-12 AS=8.01e-12 PD=1.24e-05
+ PS=1.14e-05 NRD=0.48 NRS=0.72
M19 Q QB GROUND GROUND N L=8e-07 W=2.5e-06 AD=8.01e-12 AS=9.26e-12 PD=1.14e-05
+ PS=1.24e-05 NRD=0.48 NRS=0.72
.ends

.subckt LTPR11 C D PRB QB Q GROUND VDD
M0 VDD C 7 VDD P L=8e-07 W=3e-06 AD=9.6e-12 AS=8.7e-12 PD=1.24e-05 PS=1.18e-05
+ NRD=0.366667 NRS=0.533333
M1 8 7 VDD VDD P L=8e-07 W=3e-06 AD=8.7e-12 AS=9.6e-12 PD=1.18e-05 PS=1.24e-05
+ NRD=0.366667 NRS=0.533333
M2 9 7 D VDD P L=8e-07 W=3e-06 AD=1.05e-11 AS=8.7e-12 PD=1.3e-05 PS=1.18e-05
+ NRD=0.416667 NRS=0.533333
M3 10 8 9 VDD P L=8e-07 W=3e-06 AD=8.7e-12 AS=1.05e-11 PD=1.18e-05 PS=1.3e-05
+ NRD=0.366667 NRS=0.533333
M4 VDD 9 3 VDD P L=8e-07 W=3e-06 AD=2.153e-11 AS=1.68e-11 PD=1.93e-05
+ PS=1.72e-05 NRD=0.316667 NRS=0.533333
M5 10 3 VDD VDD P L=8e-07 W=3.1e-06 AD=9.92e-12 AS=2.153e-11 PD=1.26e-05
+ PS=1.93e-05 NRD=0.516129 NRS=0.357771
M6 VDD PRB 10 VDD P L=8e-07 W=3.1e-06 AD=8.99e-12 AS=9.92e-12 PD=1.2e-05
+ PS=1.26e-05 NRD=0.354839 NRS=0.516129
M7 VDD 10 QB VDD P L=8e-07 W=4.7e-06 AD=1.718e-11 AS=1.483e-11 PD=1.68e-05
+ PS=1.58e-05 NRD=0.297872 NRS=0.382979
M8 Q QB VDD VDD P L=8e-07 W=4.7e-06 AD=1.483e-11 AS=1.718e-11 PD=1.58e-05
+ PS=1.68e-05 NRD=0.297872 NRS=0.382979
M9 GROUND C 7 GROUND N L=8e-07 W=2e-06 AD=1.589e-11 AS=7.76e-12 PD=1.95e-05
+ PS=1.14e-05 NRD=0.9 NRS=0.9
M10 8 7 GROUND GROUND N L=8e-07 W=2e-06 AD=7.73e-12 AS=1.589e-11 PD=1.14e-05
+ PS=1.95e-05 NRD=0.9 NRS=0.9
M11 9 8 D GROUND N L=8e-07 W=2e-06 AD=8.76e-12 AS=7.5e-12 PD=1.24e-05
+ PS=1.12e-05 NRD=0.6 NRS=0.85
M12 10 7 9 GROUND N L=8e-07 W=2e-06 AD=8.02e-12 AS=8.76e-12 PD=1.16e-05
+ PS=1.24e-05 NRD=0.625 NRS=0.9
M13 GROUND 9 3 GROUND N L=8e-07 W=2e-06 AD=1.66e-11 AS=1.166e-11 PD=1.76e-05
+ PS=1.53e-05 NRD=0.475 NRS=1.875
M14 21 3 GROUND GROUND N L=8e-07 W=2.4e-06 AD=3.6e-12 AS=1.66e-11 PD=5.4e-06
+ PS=1.76e-05 NRD=0.625 NRS=0.75
M15 10 PRB 21 GROUND N L=8e-07 W=2.4e-06 AD=1.644e-11 AS=3.6e-12 PD=1.84e-05
+ PS=5.4e-06 NRD=2.04167 NRS=0.625
M16 GROUND 10 QB GROUND N L=8e-07 W=2.5e-06 AD=9.26e-12 AS=8.01e-12 PD=1.24e-05
+ PS=1.14e-05 NRD=0.48 NRS=0.72
M17 Q QB GROUND GROUND N L=8e-07 W=2.5e-06 AD=8.01e-12 AS=9.26e-12 PD=1.14e-05
+ PS=1.24e-05 NRD=0.48 NRS=0.72
.ends

.subckt MX2100 S D0 D1 OUT1 GROUND VDD
M0 7 S VDD VDD P L=8e-07 W=3e-06 AD=1.215e-11 AS=9.3e-12 PD=1.41e-05 PS=1.22e-05
+ NRD=0.558333 NRS=0.6
M1 8 S D0 VDD P L=8e-07 W=3e-06 AD=1.05e-11 AS=8.7e-12 PD=1.3e-05 PS=1.18e-05
+ NRD=0.366667 NRS=0.533333
M2 D1 7 8 VDD P L=8e-07 W=3e-06 AD=8.7e-12 AS=1.05e-11 PD=1.18e-05 PS=1.3e-05
+ NRD=0.366667 NRS=0.633333
M3 OUT1 8 VDD VDD P L=8e-07 W=3.1e-06 AD=8.99e-12 AS=8.99e-12 PD=1.2e-05
+ PS=1.2e-05 NRD=0.354839 NRS=0.516129
M4 7 S GROUND GROUND N L=8e-07 W=2e-06 AD=7.76e-12 AS=7.76e-12 PD=1.14e-05
+ PS=1.14e-05 NRD=0.6 NRS=0.9
M5 8 7 D0 GROUND N L=8e-07 W=2e-06 AD=8.76e-12 AS=7.76e-12 PD=1.24e-05
+ PS=1.14e-05 NRD=0.6 NRS=0.9
M6 D1 S 8 GROUND N L=8e-07 W=2e-06 AD=7.76e-12 AS=8.76e-12 PD=1.14e-05
+ PS=1.24e-05 NRD=0.6 NRS=0.9
M7 OUT1 8 GROUND GROUND N L=8e-07 W=2e-06 AD=7.76e-12 AS=7.76e-12 PD=1.14e-05
+ PS=1.14e-05 NRD=0.6 NRS=0.9
.ends

.subckt MX4100 D1 D0 S0 D2 D3 S1 OUT1 GROUND VDD
M0 18 D1 VDD VDD P L=8e-07 W=3e-06 AD=1.65e-11 AS=8.7e-12 PD=1.7e-05 PS=1.18e-05
+ NRD=0.716667 NRS=0.533333
M1 2 6 18 VDD P L=8e-07 W=3e-06 AD=1.05e-11 AS=1.65e-11 PD=1.3e-05 PS=1.7e-05
+ NRD=0.366667 NRS=0.533333
M2 3 S0 2 VDD P L=8e-07 W=3e-06 AD=8.7e-12 AS=1.05e-11 PD=1.18e-05 PS=1.3e-05
+ NRD=0.366667 NRS=0.633333
M3 3 D0 VDD VDD P L=8e-07 W=3e-06 AD=8.7e-12 AS=8.7e-12 PD=1.18e-05 PS=1.18e-05
+ NRD=0.366667 NRS=0.533333
M4 VDD S0 6 VDD P L=8e-07 W=3e-06 AD=8.7e-12 AS=8.7e-12 PD=1.18e-05 PS=1.18e-05
+ NRD=0.366667 NRS=0.533333
M5 VDD D2 8 VDD P L=8e-07 W=3e-06 AD=8.7e-12 AS=8.7e-12 PD=1.18e-05 PS=1.18e-05
+ NRD=0.366667 NRS=0.533333
M6 9 S0 8 VDD P L=8e-07 W=3e-06 AD=1.05e-11 AS=8.7e-12 PD=1.3e-05 PS=1.18e-05
+ NRD=0.366667 NRS=0.533333
M7 10 6 9 VDD P L=8e-07 W=3e-06 AD=8.7e-12 AS=1.05e-11 PD=1.18e-05 PS=1.3e-05
+ NRD=0.366667 NRS=0.633333
M8 10 D3 VDD VDD P L=8e-07 W=3e-06 AD=8.7e-12 AS=8.7e-12 PD=1.18e-05 PS=1.18e-05
+ NRD=0.366667 NRS=0.533333
M9 12 13 9 VDD P L=8e-07 W=3e-06 AD=1.05e-11 AS=8.7e-12 PD=1.3e-05 PS=1.18e-05
+ NRD=0.366667 NRS=0.533333
M10 2 S1 12 VDD P L=8e-07 W=3e-06 AD=8.7e-12 AS=1.05e-11 PD=1.18e-05 PS=1.3e-05
+ NRD=0.366667 NRS=0.633333
M11 13 S1 VDD VDD P L=8e-07 W=3e-06 AD=1.05e-11 AS=8.7e-12 PD=1.3e-05
+ PS=1.18e-05 NRD=0.466667 NRS=0.533333
M12 OUT1 12 VDD VDD P L=8e-07 W=3e-06 AD=8.7e-12 AS=8.7e-12 PD=1.18e-05
+ PS=1.18e-05 NRD=0.366667 NRS=0.533333
M13 GROUND D1 18 GROUND N L=8e-07 W=2e-06 AD=7.76e-12 AS=1.236e-11 PD=1.14e-05
+ PS=1.6e-05 NRD=0.6 NRS=1.8
M14 2 S0 18 GROUND N L=8e-07 W=2e-06 AD=8.76e-12 AS=1.236e-11 PD=1.24e-05
+ PS=1.6e-05 NRD=0.6 NRS=0.9
M15 3 6 2 GROUND N L=8e-07 W=2e-06 AD=7.76e-12 AS=8.76e-12 PD=1.14e-05
+ PS=1.24e-05 NRD=0.6 NRS=0.9
M16 3 D0 GROUND GROUND N L=8e-07 W=2e-06 AD=7.96e-12 AS=7.76e-12 PD=1.16e-05
+ PS=1.14e-05 NRD=0.625 NRS=0.9
M17 6 S0 GROUND GROUND N L=8e-07 W=2e-06 AD=7.96e-12 AS=7.76e-12 PD=1.16e-05
+ PS=1.14e-05 NRD=0.625 NRS=0.9
M18 8 D2 GROUND GROUND N L=8e-07 W=2e-06 AD=7.96e-12 AS=7.76e-12 PD=1.16e-05
+ PS=1.14e-05 NRD=0.625 NRS=0.9
M19 9 6 8 GROUND N L=8e-07 W=2e-06 AD=8.76e-12 AS=7.76e-12 PD=1.24e-05
+ PS=1.14e-05 NRD=0.6 NRS=0.9
M20 10 S0 9 GROUND N L=8e-07 W=2e-06 AD=7.76e-12 AS=8.76e-12 PD=1.14e-05
+ PS=1.24e-05 NRD=0.6 NRS=0.9
M21 10 D3 GROUND GROUND N L=8e-07 W=2e-06 AD=7.96e-12 AS=7.76e-12 PD=1.16e-05
+ PS=1.14e-05 NRD=0.625 NRS=0.9
M22 12 S1 9 GROUND N L=8e-07 W=2e-06 AD=8.76e-12 AS=7.76e-12 PD=1.24e-05
+ PS=1.14e-05 NRD=0.6 NRS=0.9
M23 2 13 12 GROUND N L=8e-07 W=2e-06 AD=7.76e-12 AS=8.76e-12 PD=1.14e-05
+ PS=1.24e-05 NRD=0.6 NRS=0.9
M24 13 S1 GROUND GROUND N L=8e-07 W=2e-06 AD=9.95e-12 AS=7.76e-12 PD=1.32e-05
+ PS=1.14e-05 NRD=0.825 NRS=0.9
M25 OUT1 12 GROUND GROUND N L=8e-07 W=2e-06 AD=7.76e-12 AS=7.76e-12 PD=1.14e-05
+ PS=1.14e-05 NRD=0.6 NRS=0.9
.ends

.subckt NND200 IN2 IN1 OUT1 GROUND VDD
M0 OUT1 IN2 VDD VDD P L=8e-07 W=3.1e-06 AD=9.92e-12 AS=8.99e-12 PD=1.26e-05
+ PS=1.2e-05 NRD=0.354839 NRS=0.516129
M1 VDD IN1 OUT1 VDD P L=8e-07 W=3.1e-06 AD=8.99e-12 AS=9.92e-12 PD=1.2e-05
+ PS=1.26e-05 NRD=0.354839 NRS=0.516129
M2 8 IN2 GROUND GROUND N L=8e-07 W=2.4e-06 AD=2.16e-12 AS=7.96e-12 PD=4.2e-06
+ PS=1.14e-05 NRD=0.375 NRS=0.75
M3 OUT1 IN1 8 GROUND N L=8e-07 W=2.4e-06 AD=1.72e-11 AS=2.16e-12 PD=1.91e-05
+ PS=4.2e-06 NRD=2.35417 NRS=0.375
.ends

.subckt NND201 IN2 IN1 OUT1 GROUND VDD
M0 OUT1 IN2 VDD VDD P L=8e-07 W=5.1e-06 AD=1.632e-11 AS=1.479e-11 PD=1.66e-05
+ PS=1.6e-05 NRD=0.248366 NRS=0.313725
M1 VDD IN1 OUT1 VDD P L=8e-07 W=5.1e-06 AD=1.479e-11 AS=1.632e-11 PD=1.6e-05
+ PS=1.66e-05 NRD=0.215686 NRS=0.313725
M2 8 IN2 GROUND GROUND N L=8e-07 W=3.4e-06 AD=3.06e-12 AS=9.86e-12 PD=5.2e-06
+ PS=1.26e-05 NRD=0.264706 NRS=0.470588
M3 OUT1 IN1 8 GROUND N L=8e-07 W=3.4e-06 AD=2.363e-11 AS=3.06e-12 PD=2.07e-05
+ PS=5.2e-06 NRD=1.66176 NRS=0.264706
.ends

.subckt NND300 IN3 IN2 IN1 OUT1 GROUND VDD
M0 VDD IN3 OUT1 VDD P L=8e-07 W=3e-06 AD=9.75e-12 AS=8.85e-12 PD=1.25e-05
+ PS=1.19e-05 NRD=0.375 NRS=0.55
M1 OUT1 IN2 VDD VDD P L=8e-07 W=3e-06 AD=9.6e-12 AS=9.75e-12 PD=1.24e-05
+ PS=1.25e-05 NRD=0.366667 NRS=0.533333
M2 VDD IN1 OUT1 VDD P L=8e-07 W=3e-06 AD=8.7e-12 AS=9.6e-12 PD=1.18e-05
+ PS=1.24e-05 NRD=0.366667 NRS=0.533333
M3 10 IN3 GROUND GROUND N L=8e-07 W=3e-06 AD=6e-12 AS=8.85e-12 PD=7e-06
+ PS=1.19e-05 NRD=0.666667 NRS=0.55
M4 11 IN2 10 GROUND N L=8e-07 W=3e-06 AD=2.625e-12 AS=6e-12 PD=4.75e-06 PS=7e-06
+ NRD=0.291667 NRS=0.666667
M5 OUT1 IN1 11 GROUND N L=8e-07 W=3e-06 AD=8.85e-12 AS=2.625e-12 PD=1.19e-05
+ PS=4.75e-06 NRD=0.55 NRS=0.291667
.ends

.subckt NND400 IN4 IN3 IN2 IN1 OUT1 GROUND VDD
M0 VDD IN4 OUT1 VDD P L=8e-07 W=4.8e-06 AD=1.536e-11 AS=1.392e-11 PD=1.6e-05
+ PS=1.54e-05 NRD=0.263889 NRS=0.333333
M1 OUT1 IN3 VDD VDD P L=8e-07 W=4.8e-06 AD=1.536e-11 AS=1.536e-11 PD=1.6e-05
+ PS=1.6e-05 NRD=0.263889 NRS=0.333333
M2 VDD IN2 OUT1 VDD P L=8e-07 W=4.8e-06 AD=1.824e-11 AS=1.536e-11 PD=1.72e-05
+ PS=1.6e-05 NRD=0.263889 NRS=0.333333
M3 OUT1 IN1 VDD VDD P L=8e-07 W=4.8e-06 AD=1.392e-11 AS=1.824e-11 PD=1.54e-05
+ PS=1.72e-05 NRD=0.263889 NRS=0.458333
M4 12 IN4 GROUND GROUND N L=8e-07 W=4e-06 AD=4.9e-12 AS=1.16e-11 PD=6.45e-06
+ PS=1.38e-05 NRD=0.30625 NRS=0.4
M5 13 IN3 12 GROUND N L=8e-07 W=4e-06 AD=7.5e-12 AS=4.9e-12 PD=7.75e-06
+ PS=6.45e-06 NRD=0.46875 NRS=0.30625
M6 14 IN2 13 GROUND N L=8e-07 W=4e-06 AD=3e-12 AS=7.5e-12 PD=5.5e-06 PS=7.75e-06
+ NRD=0.1875 NRS=0.46875
M7 OUT1 IN1 14 GROUND N L=8e-07 W=4e-06 AD=1.32e-11 AS=3e-12 PD=1.46e-05
+ PS=5.5e-06 NRD=0.45 NRS=0.1875
.ends

.subckt NND500 IN5 IN4 IN3 IN2 IN1 OUT1 GROUND VDD
M0 OUT1 IN5 VDD VDD P L=8e-07 W=6e-06 AD=1.92e-11 AS=1.74e-11 PD=1.84e-05
+ PS=1.78e-05 NRD=0.211111 NRS=0.266667
M1 VDD IN4 OUT1 VDD P L=8e-07 W=6e-06 AD=1.92e-11 AS=1.92e-11 PD=1.84e-05
+ PS=1.84e-05 NRD=0.211111 NRS=0.266667
M2 OUT1 IN3 VDD VDD P L=8e-07 W=6e-06 AD=2.22e-11 AS=1.92e-11 PD=1.94e-05
+ PS=1.84e-05 NRD=0.211111 NRS=0.266667
M3 VDD IN2 OUT1 VDD P L=8e-07 W=6e-06 AD=1.98e-11 AS=2.22e-11 PD=1.86e-05
+ PS=1.94e-05 NRD=0.222222 NRS=0.35
M4 OUT1 IN1 VDD VDD P L=8e-07 W=6e-06 AD=1.74e-11 AS=1.98e-11 PD=1.78e-05
+ PS=1.86e-05 NRD=0.211111 NRS=0.266667
M5 14 IN5 GROUND GROUND N L=8e-07 W=5.3e-06 AD=6.36e-12 AS=1.537e-11 PD=7.7e-06
+ PS=1.64e-05 NRD=0.226415 NRS=0.301887
M6 15 IN4 14 GROUND N L=8e-07 W=5.3e-06 AD=8.215e-12 AS=6.36e-12 PD=8.4e-06
+ PS=7.7e-06 NRD=0.292453 NRS=0.226415
M7 16 IN3 15 GROUND N L=8e-07 W=5.3e-06 AD=1.961e-11 AS=8.215e-12 PD=1.27e-05
+ PS=8.4e-06 NRD=0.698113 NRS=0.292453
M8 17 IN2 16 GROUND N L=8e-07 W=5.3e-06 AD=3.445e-12 AS=1.961e-11 PD=6.6e-06
+ PS=1.27e-05 NRD=0.122642 NRS=0.698113
M9 OUT1 IN1 17 GROUND N L=8e-07 W=5.3e-06 AD=2.31e-11 AS=3.445e-12 PD=2.11e-05
+ PS=6.6e-06 NRD=0.330189 NRS=0.122642
.ends

.subckt NND600 IN1 IN3 IN2 IN6 IN5 IN4 OUT1 VDD GROUND
M0 VDD IN1 9 VDD P L=8e-07 W=3e-06 AD=9.6e-12 AS=8.7e-12 PD=1.24e-05 PS=1.18e-05
+ NRD=0.366667 NRS=0.533333
M1 9 IN2 VDD VDD P L=8e-07 W=3e-06 AD=1.065e-11 AS=9.6e-12 PD=1.31e-05
+ PS=1.24e-05 NRD=0.391667 NRS=0.533333
M2 VDD IN3 9 VDD P L=8e-07 W=3e-06 AD=9.6e-12 AS=1.065e-11 PD=1.24e-05
+ PS=1.31e-05 NRD=0.366667 NRS=0.6
M3 8 IN6 VDD VDD P L=8e-07 W=3e-06 AD=9.6e-12 AS=9.6e-12 PD=1.24e-05 PS=1.24e-05
+ NRD=0.366667 NRS=0.533333
M4 VDD IN5 8 VDD P L=8e-07 W=3e-06 AD=9.6e-12 AS=9.6e-12 PD=1.24e-05 PS=1.24e-05
+ NRD=0.366667 NRS=0.533333
M5 8 IN4 VDD VDD P L=8e-07 W=3e-06 AD=9e-12 AS=9.6e-12 PD=1.2e-05 PS=1.24e-05
+ NRD=0.383333 NRS=0.533333
M6 23 8 10 VDD P L=8e-07 W=5.3e-06 AD=4.9025e-12 AS=1.537e-11 PD=7.15e-06
+ PS=1.64e-05 NRD=0.174528 NRS=0.301887
M7 VDD 9 23 VDD P L=8e-07 W=5.3e-06 AD=1.692e-11 AS=4.9025e-12 PD=1.74e-05
+ PS=7.15e-06 NRD=0.301887 NRS=0.174528
M8 OUT1 10 VDD VDD P L=8e-07 W=3.1e-06 AD=1.403e-11 AS=1.692e-11 PD=1.58e-05
+ PS=1.74e-05 NRD=0.397849 NRS=0.580645
M9 24 IN1 9 GROUND N L=8e-07 W=3e-06 AD=1.5e-12 AS=8.7e-12 PD=4e-06 PS=1.18e-05
+ NRD=0.166667 NRS=0.533333
M10 25 IN2 24 GROUND N L=8e-07 W=3e-06 AD=5.85e-12 AS=1.5e-12 PD=6.9e-06
+ PS=4e-06 NRD=0.65 NRS=0.166667
M11 GROUND IN3 25 GROUND N L=8e-07 W=3e-06 AD=1.14e-11 AS=5.85e-12 PD=1.36e-05
+ PS=6.9e-06 NRD=0.533333 NRS=0.65
M12 26 IN6 GROUND GROUND N L=8e-07 W=3e-06 AD=5.25e-12 AS=1.14e-11 PD=6.5e-06
+ PS=1.36e-05 NRD=0.583333 NRS=0.733333
M13 27 IN5 26 GROUND N L=8e-07 W=3e-06 AD=5.25e-12 AS=5.25e-12 PD=6.5e-06
+ PS=6.5e-06 NRD=0.583333 NRS=0.583333
M14 8 IN4 27 GROUND N L=8e-07 W=3e-06 AD=8.7e-12 AS=5.25e-12 PD=1.18e-05
+ PS=6.5e-06 NRD=0.533333 NRS=0.583333
M15 10 8 GROUND GROUND N L=8e-07 W=2.1e-06 AD=9.9e-12 AS=7.81e-12 PD=1.32e-05
+ PS=1.14e-05 NRD=0.452381 NRS=0.857143
M16 GROUND 9 10 GROUND N L=8e-07 W=2.1e-06 AD=8.81e-12 AS=9.9e-12 PD=1.24e-05
+ PS=1.32e-05 NRD=0.857143 NRS=0.552381
M17 OUT1 10 GROUND GROUND N L=8e-07 W=2e-06 AD=9.06e-12 AS=8.81e-12 PD=1.24e-05
+ PS=1.24e-05 NRD=0.475 NRS=0.9
.ends

.subckt NND700 IN1 IN2 IN4 IN3 IN7 IN6 IN5 OUT1 VDD GROUND
M0 10 IN1 VDD VDD P L=8e-07 W=4.8e-06 AD=1.536e-11 AS=1.392e-11 PD=1.6e-05
+ PS=1.54e-05 NRD=0.229167 NRS=0.333333
M1 VDD IN2 10 VDD P L=8e-07 W=4.8e-06 AD=1.536e-11 AS=1.536e-11 PD=1.6e-05
+ PS=1.6e-05 NRD=0.229167 NRS=0.333333
M2 10 IN3 VDD VDD P L=8e-07 W=4.8e-06 AD=1.992e-11 AS=1.536e-11 PD=1.79e-05
+ PS=1.6e-05 NRD=0.328125 NRS=0.333333
M3 VDD IN4 10 VDD P L=8e-07 W=4.8e-06 AD=1.23e-11 AS=1.992e-11 PD=1.6e-05
+ PS=1.79e-05 NRD=0.229167 NRS=0.333333
M4 9 IN7 VDD VDD P L=8e-07 W=3e-06 AD=9.6e-12 AS=1.23e-11 PD=1.24e-05 PS=1.6e-05
+ NRD=0.366667 NRS=0.533333
M5 VDD IN6 9 VDD P L=8e-07 W=3e-06 AD=9.6e-12 AS=9.6e-12 PD=1.24e-05 PS=1.24e-05
+ NRD=0.366667 NRS=0.533333
M6 9 IN5 VDD VDD P L=8e-07 W=3e-06 AD=9e-12 AS=9.6e-12 PD=1.2e-05 PS=1.24e-05
+ NRD=0.383333 NRS=0.533333
M7 25 9 11 VDD P L=8e-07 W=5.3e-06 AD=4.9025e-12 AS=1.537e-11 PD=7.15e-06
+ PS=1.64e-05 NRD=0.174528 NRS=0.301887
M8 VDD 10 25 VDD P L=8e-07 W=5.3e-06 AD=1.692e-11 AS=4.9025e-12 PD=1.74e-05
+ PS=7.15e-06 NRD=0.301887 NRS=0.174528
M9 OUT1 11 VDD VDD P L=8e-07 W=3.1e-06 AD=1.403e-11 AS=1.692e-11 PD=1.58e-05
+ PS=1.74e-05 NRD=0.397849 NRS=0.580645
M10 26 IN1 10 GROUND N L=8e-07 W=4e-06 AD=2.3e-12 AS=1.16e-11 PD=5.15e-06
+ PS=1.38e-05 NRD=0.14375 NRS=0.4
M11 27 IN2 26 GROUND N L=8e-07 W=4e-06 AD=7.4e-12 AS=2.3e-12 PD=7.7e-06
+ PS=5.15e-06 NRD=0.4625 NRS=0.14375
M12 28 IN3 27 GROUND N L=8e-07 W=4e-06 AD=8.9e-12 AS=7.4e-12 PD=8.45e-06
+ PS=7.7e-06 NRD=0.55625 NRS=0.4625
M13 GROUND IN4 28 GROUND N L=8e-07 W=4e-06 AD=1.195e-11 AS=8.9e-12 PD=1.44e-05
+ PS=8.45e-06 NRD=0.4 NRS=0.55625
M14 29 IN7 GROUND GROUND N L=8e-07 W=3e-06 AD=5.25e-12 AS=1.195e-11 PD=6.5e-06
+ PS=1.44e-05 NRD=0.583333 NRS=0.533333
M15 30 IN6 29 GROUND N L=8e-07 W=3e-06 AD=5.25e-12 AS=5.25e-12 PD=6.5e-06
+ PS=6.5e-06 NRD=0.583333 NRS=0.583333
M16 9 IN5 30 GROUND N L=8e-07 W=3e-06 AD=8.7e-12 AS=5.25e-12 PD=1.18e-05
+ PS=6.5e-06 NRD=0.533333 NRS=0.583333
M17 11 9 GROUND GROUND N L=8e-07 W=2.1e-06 AD=9.9e-12 AS=7.81e-12 PD=1.32e-05
+ PS=1.14e-05 NRD=0.452381 NRS=0.857143
M18 GROUND 10 11 GROUND N L=8e-07 W=2.1e-06 AD=8.81e-12 AS=9.9e-12 PD=1.24e-05
+ PS=1.32e-05 NRD=0.857143 NRS=0.552381
M19 OUT1 11 GROUND GROUND N L=8e-07 W=2e-06 AD=9.06e-12 AS=8.81e-12 PD=1.24e-05
+ PS=1.24e-05 NRD=0.475 NRS=0.9
.ends

.subckt NOR200 IN1 IN2 OUT1 VDD GROUND
M0 8 IN1 VDD VDD P L=8e-07 W=5.3e-06 AD=4.9025e-12 AS=1.537e-11 PD=7.15e-06
+ PS=1.64e-05 NRD=0.174528 NRS=0.301887
M1 OUT1 IN2 8 VDD P L=8e-07 W=5.3e-06 AD=1.537e-11 AS=4.9025e-12 PD=1.64e-05
+ PS=7.15e-06 NRD=0.301887 NRS=0.174528
M2 OUT1 IN1 GROUND GROUND N L=8e-07 W=2.1e-06 AD=1.25e-11 AS=7.81e-12
+ PD=1.52e-05 PS=1.14e-05 NRD=0.857143 NRS=0.857143
M3 GROUND IN2 OUT1 GROUND N L=8e-07 W=2.1e-06 AD=9.37e-12 AS=1.25e-11
+ PD=1.26e-05 PS=1.52e-05 NRD=0.619048 NRS=0.857143
.ends

.subckt NOR201 IN1 IN2 OUT1 VDD GROUND
M0 8 IN1 VDD VDD P L=8e-07 W=8.5e-06 AD=7.8625e-12 AS=2.465e-11 PD=1.035e-05
+ PS=2.28e-05 NRD=0.108824 NRS=0.188235
M1 OUT1 IN2 8 VDD P L=8e-07 W=8.5e-06 AD=2.465e-11 AS=7.8625e-12 PD=2.28e-05
+ PS=1.035e-05 NRD=0.188235 NRS=0.108824
M2 OUT1 IN1 GROUND GROUND N L=8e-07 W=2.8e-06 AD=1.372e-11 AS=8.68e-12
+ PD=1.56e-05 PS=1.18e-05 NRD=0.339286 NRS=0.642857
M3 GROUND IN2 OUT1 GROUND N L=8e-07 W=2.8e-06 AD=1.102e-11 AS=1.372e-11
+ PD=1.36e-05 PS=1.56e-05 NRD=0.339286 NRS=0.514286
.ends

.subckt NOR300 IN1 IN2 IN3 OUT1 VDD GROUND
M0 10 IN1 VDD VDD P L=8e-07 W=8.5e-06 AD=8.5e-12 AS=2.661e-11 PD=1.05e-05
+ PS=2.34e-05 NRD=0.117647 NRS=0.211765
M1 11 IN2 10 VDD P L=8e-07 W=8.5e-06 AD=1.6575e-11 AS=8.5e-12 PD=1.24e-05
+ PS=1.05e-05 NRD=0.229412 NRS=0.117647
M2 OUT1 IN3 11 VDD P L=8e-07 W=8.5e-06 AD=3.23e-11 AS=1.6575e-11 PD=2.46e-05
+ PS=1.24e-05 NRD=0.247059 NRS=0.229412
M3 OUT1 IN1 GROUND GROUND N L=8e-07 W=2.6e-06 AD=1.365e-11 AS=7.54e-12
+ PD=1.57e-05 PS=1.1e-05 NRD=0.365385 NRS=0.615385
M4 GROUND IN2 OUT1 GROUND N L=8e-07 W=2.6e-06 AD=8.32e-12 AS=1.365e-11
+ PD=1.16e-05 PS=1.57e-05 NRD=0.615385 NRS=0.489231
M5 OUT1 IN3 GROUND GROUND N L=8e-07 W=2.6e-06 AD=1.17e-11 AS=8.32e-12
+ PD=1.42e-05 PS=1.16e-05 NRD=0.365385 NRS=0.615385
.ends

.subckt NOR400 IN1 IN2 IN3 IN4 OUT1 VDD GROUND
M0 12 IN1 VDD VDD P L=8e-07 W=1.51e-05 AD=2.948e-11 AS=4.00525e-11 PD=1.985e-05
+ PS=3.37e-05 NRD=0.157285 NRS=0.108091
M1 13 IN2 12 VDD P L=8e-07 W=1.51e-05 AD=3.204e-11 AS=2.948e-11 PD=2.025e-05
+ PS=1.985e-05 NRD=0.17053 NRS=0.157285
M2 14 IN3 13 VDD P L=8e-07 W=1.51e-05 AD=2.404e-11 AS=3.204e-11 PD=1.9e-05
+ PS=2.025e-05 NRD=0.129139 NRS=0.17053
M3 OUT1 IN4 14 VDD P L=8e-07 W=1.51e-05 AD=5.10175e-11 AS=2.404e-11 PD=3.81e-05
+ PS=1.9e-05 NRD=0.140728 NRS=0.129139
M4 GROUND IN1 OUT1 GROUND N L=8e-07 W=3.6e-06 AD=2.646e-11 AS=1.272e-11
+ PD=2.19e-05 PS=1.46e-05 NRD=0.881944 NRS=0.5
M5 OUT1 IN2 GROUND GROUND N L=8e-07 W=3.6e-06 AD=1.542e-11 AS=2.646e-11
+ PD=1.61e-05 PS=2.19e-05 NRD=0.333333 NRS=0.444444
M6 GROUND IN3 OUT1 GROUND N L=8e-07 W=3.6e-06 AD=1.152e-11 AS=1.542e-11
+ PD=1.36e-05 PS=1.61e-05 NRD=0.305556 NRS=0.569444
M7 OUT1 IN4 GROUND GROUND N L=8e-07 W=3.6e-06 AD=1.272e-11 AS=1.152e-11
+ PD=1.46e-05 PS=1.36e-05 NRD=0.333333 NRS=0.444444
.ends

.subckt NOR500 IN3 IN4 IN5 IN1 IN2 OUT1 GROUND VDD
M0 20 IN3 VDD VDD P L=8e-07 W=8.5e-06 AD=8.5e-12 AS=2.465e-11 PD=1.05e-05
+ PS=2.28e-05 NRD=0.117647 NRS=0.188235
M1 21 IN4 20 VDD P L=8e-07 W=8.5e-06 AD=1.42375e-11 AS=8.5e-12 PD=1.185e-05
+ PS=1.05e-05 NRD=0.197059 NRS=0.117647
M2 8 IN5 21 VDD P L=8e-07 W=8.5e-06 AD=3.23e-11 AS=1.42375e-11 PD=2.46e-05
+ PS=1.185e-05 NRD=0.188235 NRS=0.197059
M3 22 IN1 VDD VDD P L=8e-07 W=5.3e-06 AD=5.565e-12 AS=1.537e-11 PD=7.4e-06
+ PS=1.64e-05 NRD=0.198113 NRS=0.301887
M4 9 IN2 22 VDD P L=8e-07 W=5.3e-06 AD=1.537e-11 AS=5.565e-12 PD=1.64e-05
+ PS=7.4e-06 NRD=0.301887 NRS=0.198113
M5 10 8 VDD VDD P L=8e-07 W=3.5e-06 AD=1.12e-11 AS=1.015e-11 PD=1.34e-05
+ PS=1.28e-05 NRD=0.314286 NRS=0.457143
M6 VDD 9 10 VDD P L=8e-07 W=3.5e-06 AD=1.145e-11 AS=1.12e-11 PD=1.36e-05
+ PS=1.34e-05 NRD=0.314286 NRS=0.457143
M7 OUT1 10 VDD VDD P L=8e-07 W=3.3e-06 AD=9.57e-12 AS=1.145e-11 PD=1.24e-05
+ PS=1.36e-05 NRD=0.333333 NRS=0.515152
M8 8 IN3 GROUND GROUND N L=8e-07 W=2.9e-06 AD=1.4805e-11 AS=8.41e-12 PD=1.63e-05
+ PS=1.16e-05 NRD=0.327586 NRS=0.551724
M9 GROUND IN4 8 GROUND N L=8e-07 W=2.9e-06 AD=9.28e-12 AS=1.4805e-11 PD=1.22e-05
+ PS=1.63e-05 NRD=0.551724 NRS=0.438621
M10 8 IN5 GROUND GROUND N L=8e-07 W=2.9e-06 AD=1.263e-11 AS=9.28e-12 PD=1.48e-05
+ PS=1.22e-05 NRD=0.327586 NRS=0.551724
M11 9 IN1 GROUND GROUND N L=8e-07 W=2.1e-06 AD=2.524e-11 AS=7.81e-12 PD=2.5e-05
+ PS=1.14e-05 NRD=0.857143 NRS=0.857143
M12 GROUND IN2 9 GROUND N L=8e-07 W=2.1e-06 AD=1.721e-11 AS=2.524e-11
+ PD=1.98e-05 PS=2.5e-05 NRD=0.857143 NRS=0.857143
M13 23 8 GROUND GROUND N L=8e-07 W=2.4e-06 AD=2.22e-12 AS=1.721e-11 PD=4.25e-06
+ PS=1.98e-05 NRD=0.385417 NRS=1.32576
M14 10 9 23 GROUND N L=8e-07 W=2.4e-06 AD=1.139e-11 AS=2.22e-12 PD=1.41e-05
+ PS=4.25e-06 NRD=0.541667 NRS=0.385417
M15 OUT1 10 GROUND GROUND N L=8e-07 W=2e-06 AD=7.76e-12 AS=7.76e-12 PD=1.14e-05
+ PS=1.14e-05 NRD=0.6 NRS=0.9
.ends

.subckt NOR600 IN1 IN2 IN3 OUT1 IN6 IN5 IN4 VDD GROUND
M0 22 IN1 VDD VDD P L=8e-07 W=8.5e-06 AD=8.5e-12 AS=2.661e-11 PD=1.05e-05
+ PS=2.34e-05 NRD=0.117647 NRS=0.211765
M1 23 IN2 22 VDD P L=8e-07 W=8.5e-06 AD=1.6575e-11 AS=8.5e-12 PD=1.24e-05
+ PS=1.05e-05 NRD=0.229412 NRS=0.117647
M2 8 IN3 23 VDD P L=8e-07 W=8.5e-06 AD=3.23e-11 AS=1.6575e-11 PD=2.46e-05
+ PS=1.24e-05 NRD=0.247059 NRS=0.229412
M3 9 8 VDD VDD P L=8e-07 W=3e-06 AD=9.6e-12 AS=8.7e-12 PD=1.24e-05 PS=1.18e-05
+ NRD=0.366667 NRS=0.533333
M4 VDD 10 9 VDD P L=8e-07 W=3e-06 AD=1.005e-11 AS=9.6e-12 PD=1.3e-05 PS=1.24e-05
+ NRD=0.366667 NRS=0.533333
M5 OUT1 9 VDD VDD P L=8e-07 W=3.3e-06 AD=9.57e-12 AS=1.005e-11 PD=1.24e-05
+ PS=1.3e-05 NRD=0.333333 NRS=0.484848
M6 24 IN6 10 VDD P L=8e-07 W=8.5e-06 AD=1.6575e-11 AS=3.23e-11 PD=1.24e-05
+ PS=2.46e-05 NRD=0.229412 NRS=0.247059
M7 25 IN5 24 VDD P L=8e-07 W=8.5e-06 AD=8.5e-12 AS=1.6575e-11 PD=1.05e-05
+ PS=1.24e-05 NRD=0.117647 NRS=0.229412
M8 VDD IN4 25 VDD P L=8e-07 W=8.5e-06 AD=2.661e-11 AS=8.5e-12 PD=2.34e-05
+ PS=1.05e-05 NRD=0.211765 NRS=0.117647
M9 8 IN1 GROUND GROUND N L=8e-07 W=2.6e-06 AD=1.586e-11 AS=7.54e-12 PD=1.74e-05
+ PS=1.1e-05 NRD=0.692308 NRS=0.615385
M10 GROUND IN2 8 GROUND N L=8e-07 W=2.6e-06 AD=8.32e-12 AS=1.586e-11 PD=1.16e-05
+ PS=1.74e-05 NRD=0.615385 NRS=0.692308
M11 8 IN3 GROUND GROUND N L=8e-07 W=2.6e-06 AD=1.716e-11 AS=8.32e-12 PD=1.84e-05
+ PS=1.16e-05 NRD=0.692308 NRS=0.615385
M12 26 8 GROUND GROUND N L=8e-07 W=2e-06 AD=1.3e-12 AS=9.58e-12 PD=3.3e-06
+ PS=1.28e-05 NRD=0.325 NRS=1.15
M13 9 10 26 GROUND N L=8e-07 W=2e-06 AD=8.41e-12 AS=1.3e-12 PD=1.19e-05
+ PS=3.3e-06 NRD=0.9 NRS=0.325
M14 OUT1 9 GROUND GROUND N L=8e-07 W=2e-06 AD=7.76e-12 AS=7.76e-12 PD=1.14e-05
+ PS=1.14e-05 NRD=0.6 NRS=0.9
M15 GROUND IN6 10 GROUND N L=8e-07 W=2.6e-06 AD=8.32e-12 AS=1.989e-11
+ PD=1.16e-05 PS=2.05e-05 NRD=0.615385 NRS=0.692308
M16 10 IN5 GROUND GROUND N L=8e-07 W=2.6e-06 AD=1.586e-11 AS=8.32e-12
+ PD=1.74e-05 PS=1.16e-05 NRD=0.692308 NRS=0.615385
M17 GROUND IN4 10 GROUND N L=8e-07 W=2.6e-06 AD=7.54e-12 AS=1.586e-11 PD=1.1e-05
+ PS=1.74e-05 NRD=0.615385 NRS=0.692308
.ends

.subckt NOR700 IN1 IN2 IN3 OUT1 IN4 IN5 IN6 IN7 GROUND VDD
M0 25 IN1 VDD VDD P L=8e-07 W=8.5e-06 AD=8.5e-12 AS=2.661e-11 PD=1.05e-05
+ PS=2.34e-05 NRD=0.117647 NRS=0.211765
M1 26 IN2 25 VDD P L=8e-07 W=8.5e-06 AD=1.6575e-11 AS=8.5e-12 PD=1.24e-05
+ PS=1.05e-05 NRD=0.229412 NRS=0.117647
M2 9 IN3 26 VDD P L=8e-07 W=8.5e-06 AD=3.23e-11 AS=1.6575e-11 PD=2.46e-05
+ PS=1.24e-05 NRD=0.247059 NRS=0.229412
M3 10 9 VDD VDD P L=8e-07 W=3e-06 AD=9.6e-12 AS=8.7e-12 PD=1.24e-05 PS=1.18e-05
+ NRD=0.366667 NRS=0.533333
M4 VDD 12 10 VDD P L=8e-07 W=3e-06 AD=1.0275e-11 AS=9.6e-12 PD=1.3e-05
+ PS=1.24e-05 NRD=0.366667 NRS=0.533333
M5 OUT1 10 VDD VDD P L=8e-07 W=3.3e-06 AD=9.57e-12 AS=1.0275e-11 PD=1.24e-05
+ PS=1.3e-05 NRD=0.333333 NRS=0.484848
M6 27 IN4 12 VDD P L=8e-07 W=1.51e-05 AD=2.404e-11 AS=4.26225e-11 PD=1.9e-05
+ PS=3.81e-05 NRD=0.129139 NRS=0.108012
M7 28 IN5 27 VDD P L=8e-07 W=1.51e-05 AD=3.204e-11 AS=2.404e-11 PD=2.025e-05
+ PS=1.9e-05 NRD=0.17053 NRS=0.129139
M8 29 IN6 28 VDD P L=8e-07 W=1.51e-05 AD=2.948e-11 AS=3.204e-11 PD=1.985e-05
+ PS=2.025e-05 NRD=0.157285 NRS=0.17053
M9 VDD IN7 29 VDD P L=8e-07 W=1.51e-05 AD=4.00525e-11 AS=2.948e-11 PD=3.37e-05
+ PS=1.985e-05 NRD=0.121192 NRS=0.157285
M10 9 IN1 GROUND GROUND N L=8e-07 W=2.6e-06 AD=1.365e-11 AS=7.54e-12 PD=1.57e-05
+ PS=1.1e-05 NRD=0.365385 NRS=0.615385
M11 GROUND IN2 9 GROUND N L=8e-07 W=2.6e-06 AD=8.32e-12 AS=1.365e-11 PD=1.16e-05
+ PS=1.57e-05 NRD=0.615385 NRS=0.489231
M12 9 IN3 GROUND GROUND N L=8e-07 W=2.6e-06 AD=1.17e-11 AS=8.32e-12 PD=1.42e-05
+ PS=1.16e-05 NRD=0.365385 NRS=0.615385
M13 30 9 GROUND GROUND N L=8e-07 W=2e-06 AD=1.8e-12 AS=7.76e-12 PD=3.8e-06
+ PS=1.14e-05 NRD=0.45 NRS=0.9
M14 10 12 30 GROUND N L=8e-07 W=2e-06 AD=7.76e-12 AS=1.8e-12 PD=1.14e-05
+ PS=3.8e-06 NRD=0.9 NRS=0.45
M15 OUT1 10 GROUND GROUND N L=8e-07 W=2e-06 AD=7.76e-12 AS=7.76e-12 PD=1.14e-05
+ PS=1.14e-05 NRD=0.6 NRS=0.9
M16 GROUND IN4 12 GROUND N L=8e-07 W=3.6e-06 AD=1.152e-11 AS=1.272e-11
+ PD=1.36e-05 PS=1.46e-05 NRD=0.305556 NRS=0.5
M17 12 IN5 GROUND GROUND N L=8e-07 W=3.6e-06 AD=1.542e-11 AS=1.152e-11
+ PD=1.61e-05 PS=1.36e-05 NRD=0.368056 NRS=0.444444
M18 GROUND IN6 12 GROUND N L=8e-07 W=3.6e-06 AD=2.646e-11 AS=1.542e-11
+ PD=2.19e-05 PS=1.61e-05 NRD=0.305556 NRS=0.5
M19 12 IN7 GROUND GROUND N L=8e-07 W=3.6e-06 AD=1.272e-11 AS=2.646e-11
+ PD=1.46e-05 PS=2.19e-05 NRD=0.333333 NRS=1.59722
.ends

.subckt OAI400 OUT1 IN2 IN1 IN3 IN4 VDD GROUND
M0 13 IN2 OUT1 VDD P L=8e-07 W=5.5e-06 AD=2.75e-12 AS=1.731e-11 PD=6.5e-06
+ PS=1.74e-05 NRD=0.0909091 NRS=0.327273
M1 VDD IN1 13 VDD P L=8e-07 W=5.5e-06 AD=5.345e-11 AS=2.75e-12 PD=2.97e-05
+ PS=6.5e-06 NRD=0.236364 NRS=0.0909091
M2 14 IN3 VDD VDD P L=8e-07 W=5.5e-06 AD=3.025e-12 AS=5.345e-11 PD=6.6e-06
+ PS=2.97e-05 NRD=0.1 NRS=0.241897
M3 OUT1 IN4 14 VDD P L=8e-07 W=5.5e-06 AD=1.731e-11 AS=3.025e-12 PD=1.74e-05
+ PS=6.6e-06 NRD=0.327273 NRS=0.1
M4 OUT1 IN2 8 GROUND N L=8e-07 W=2.9e-06 AD=1.827e-11 AS=8.41e-12 PD=1.9e-05
+ PS=1.16e-05 NRD=0.62069 NRS=0.551724
M5 8 IN1 OUT1 GROUND N L=8e-07 W=2.9e-06 AD=1.363e-11 AS=1.827e-11 PD=1.52e-05
+ PS=1.9e-05 NRD=0.551724 NRS=0.62069
M6 GROUND IN3 8 GROUND N L=8e-07 W=2.9e-06 AD=9.28e-12 AS=1.363e-11 PD=1.22e-05
+ PS=1.52e-05 NRD=0.37931 NRS=1.06897
M7 8 IN4 GROUND GROUND N L=8e-07 W=2.9e-06 AD=8.41e-12 AS=9.28e-12 PD=1.16e-05
+ PS=1.22e-05 NRD=0.37931 NRS=0.551724
.ends

.subckt OR2100 IN2 IN1 OUT1 GROUND VDD
M0 10 IN2 VDD VDD P L=8e-07 W=3.6e-06 AD=3.15e-12 AS=1.044e-11 PD=5.35e-06
+ PS=1.3e-05 NRD=0.243056 NRS=0.444444
M1 5 IN1 10 VDD P L=8e-07 W=3.6e-06 AD=1.044e-11 AS=3.15e-12 PD=1.3e-05
+ PS=5.35e-06 NRD=0.444444 NRS=0.243056
M2 OUT1 5 VDD VDD P L=8e-07 W=3.1e-06 AD=8.99e-12 AS=8.99e-12 PD=1.2e-05
+ PS=1.2e-05 NRD=0.354839 NRS=0.516129
M3 5 IN2 GROUND GROUND N L=8e-07 W=2e-06 AD=1.24e-11 AS=7.76e-12 PD=1.52e-05
+ PS=1.14e-05 NRD=0.9 NRS=0.9
M4 GROUND IN1 5 GROUND N L=8e-07 W=2e-06 AD=8.76e-12 AS=1.24e-11 PD=1.24e-05
+ PS=1.52e-05 NRD=0.9 NRS=0.9
M5 OUT1 5 GROUND GROUND N L=8e-07 W=2e-06 AD=1.14e-11 AS=8.76e-12 PD=1.42e-05
+ PS=1.24e-05 NRD=0.9 NRS=0.9
.ends

.subckt OR2101 IN1 IN2 OUT1 GROUND VDD
M0 10 IN1 VDD VDD P L=8e-07 W=5.3e-06 AD=4.1075e-12 AS=1.76e-11 PD=6.85e-06
+ PS=1.77e-05 NRD=0.146226 NRS=0.339623
M1 5 IN2 10 VDD P L=8e-07 W=5.3e-06 AD=1.537e-11 AS=4.1075e-12 PD=1.64e-05
+ PS=6.85e-06 NRD=0.301887 NRS=0.146226
M2 OUT1 5 VDD VDD P L=8e-07 W=4e-06 AD=1.16e-11 AS=1.16e-11 PD=1.38e-05
+ PS=1.38e-05 NRD=0.275 NRS=0.4
M3 5 IN1 GROUND GROUND N L=8e-07 W=2.1e-06 AD=1.25e-11 AS=7.81e-12 PD=1.52e-05
+ PS=1.14e-05 NRD=0.857143 NRS=0.857143
M4 GROUND IN2 5 GROUND N L=8e-07 W=2.1e-06 AD=8.96e-12 AS=1.25e-11 PD=1.24e-05
+ PS=1.52e-05 NRD=0.857143 NRS=0.857143
M5 OUT1 5 GROUND GROUND N L=8e-07 W=2.3e-06 AD=1.155e-11 AS=8.96e-12 PD=1.42e-05
+ PS=1.24e-05 NRD=0.413043 NRS=0.782609
.ends

.subckt OR3100 IN1 IN2 IN3 OUT1 GROUND VDD
M0 12 IN1 VDD VDD P L=8e-07 W=8.5e-06 AD=8.5e-12 AS=2.465e-11 PD=1.05e-05
+ PS=2.28e-05 NRD=0.117647 NRS=0.188235
M1 13 IN2 12 VDD P L=8e-07 W=8.5e-06 AD=1.12625e-11 AS=8.5e-12 PD=1.115e-05
+ PS=1.05e-05 NRD=0.155882 NRS=0.117647
M2 6 IN3 13 VDD P L=8e-07 W=8.5e-06 AD=3.23e-11 AS=1.12625e-11 PD=2.46e-05
+ PS=1.115e-05 NRD=0.188235 NRS=0.155882
M3 OUT1 6 VDD VDD P L=8e-07 W=3.1e-06 AD=8.99e-12 AS=8.99e-12 PD=1.2e-05
+ PS=1.2e-05 NRD=0.354839 NRS=0.516129
M4 6 IN1 GROUND GROUND N L=8e-07 W=2.6e-06 AD=1.365e-11 AS=7.54e-12 PD=1.57e-05
+ PS=1.1e-05 NRD=0.365385 NRS=0.615385
M5 GROUND IN2 6 GROUND N L=8e-07 W=2.6e-06 AD=8.32e-12 AS=1.365e-11 PD=1.16e-05
+ PS=1.57e-05 NRD=0.615385 NRS=0.489231
M6 6 IN3 GROUND GROUND N L=8e-07 W=2.6e-06 AD=1.17e-11 AS=8.32e-12 PD=1.42e-05
+ PS=1.16e-05 NRD=0.365385 NRS=0.615385
M7 OUT1 6 GROUND GROUND N L=8e-07 W=2e-06 AD=7.76e-12 AS=7.76e-12 PD=1.14e-05
+ PS=1.14e-05 NRD=0.6 NRS=0.9
.ends

.subckt OR4100 IN1 IN2 IN3 IN4 OUT1 GROUND VDD
M0 14 IN1 VDD VDD P L=8e-07 W=1.51e-05 AD=2.948e-11 AS=4.00525e-11 PD=1.985e-05
+ PS=3.37e-05 NRD=0.157285 NRS=0.108091
M1 15 IN2 14 VDD P L=8e-07 W=1.51e-05 AD=3.204e-11 AS=2.948e-11 PD=2.025e-05
+ PS=1.985e-05 NRD=0.17053 NRS=0.157285
M2 16 IN3 15 VDD P L=8e-07 W=1.51e-05 AD=2.404e-11 AS=3.204e-11 PD=1.9e-05
+ PS=2.025e-05 NRD=0.129139 NRS=0.17053
M3 6 IN4 16 VDD P L=8e-07 W=1.51e-05 AD=4.45175e-11 AS=2.404e-11 PD=3.6e-05
+ PS=1.9e-05 NRD=0.122517 NRS=0.129139
M4 OUT1 6 VDD VDD P L=8e-07 W=3e-06 AD=9.3e-12 AS=8.7e-12 PD=1.22e-05
+ PS=1.18e-05 NRD=0.4 NRS=0.533333
M5 GROUND IN1 6 GROUND N L=8e-07 W=3.6e-06 AD=2.646e-11 AS=1.272e-11 PD=2.19e-05
+ PS=1.46e-05 NRD=0.881944 NRS=0.5
M6 6 IN2 GROUND GROUND N L=8e-07 W=3.6e-06 AD=1.542e-11 AS=2.646e-11 PD=1.61e-05
+ PS=2.19e-05 NRD=0.333333 NRS=0.444444
M7 GROUND IN3 6 GROUND N L=8e-07 W=3.6e-06 AD=1.152e-11 AS=1.542e-11 PD=1.36e-05
+ PS=1.61e-05 NRD=0.305556 NRS=0.569444
M8 6 IN4 GROUND GROUND N L=8e-07 W=3.6e-06 AD=1.272e-11 AS=1.152e-11 PD=1.46e-05
+ PS=1.36e-05 NRD=0.333333 NRS=0.444444
M9 OUT1 6 GROUND GROUND N L=8e-07 W=2e-06 AD=7.76e-12 AS=7.76e-12 PD=1.14e-05
+ PS=1.14e-05 NRD=0.6 NRS=0.9
.ends

.subckt ORND00 IN3 IN2 IN1 OUT1 GROUND VDD
M0 OUT1 IN3 VDD VDD P L=8e-07 W=4.1e-06 AD=1.558e-11 AS=1.189e-11 PD=1.58e-05
+ PS=1.4e-05 NRD=0.268293 NRS=0.390244
M1 11 IN2 OUT1 VDD P L=8e-07 W=4.1e-06 AD=2.05e-12 AS=1.558e-11 PD=5.1e-06
+ PS=1.58e-05 NRD=0.121951 NRS=0.536585
M2 VDD IN1 11 VDD P L=8e-07 W=4.1e-06 AD=1.189e-11 AS=2.05e-12 PD=1.4e-05
+ PS=5.1e-06 NRD=0.390244 NRS=0.121951
M3 12 IN2 OUT1 GROUND N L=8e-07 W=2.7e-06 AD=5.22e-12 AS=8.76e-12 PD=5.66667e-06
+ PS=1.19e-05 NRD=1.07407 NRS=0.666667
M4 12 IN3 GROUND GROUND N L=8e-07 W=2.7e-06 AD=5.22e-12 AS=7.83e-12
+ PD=5.66667e-06 PS=1.12e-05 NRD=1.07407 NRS=0.592593
M5 OUT1 IN1 12 GROUND N L=8e-07 W=2.7e-06 AD=8.235e-12 AS=5.22e-12 PD=1.15e-05
+ PS=5.66667e-06 NRD=0.648148 NRS=1.07407
.ends

.subckt TBUF00 EN IN1 OUT1 VDD GROUND
M0 VDD EN 4 VDD P L=8e-07 W=3e-06 AD=9e-12 AS=8.7e-12 PD=1.2e-05 PS=1.18e-05
+ NRD=0.383333 NRS=0.533333
M1 5 4 6 VDD P L=8e-07 W=3e-06 AD=8.7e-12 AS=9e-12 PD=1.18e-05 PS=1.2e-05
+ NRD=0.366667 NRS=0.533333
M2 5 IN1 VDD VDD P L=8e-07 W=3e-06 AD=9.6e-12 AS=9e-12 PD=1.24e-05 PS=1.2e-05
+ NRD=0.366667 NRS=0.533333
M3 VDD EN 5 VDD P L=8e-07 W=3e-06 AD=9.75e-12 AS=9.6e-12 PD=1.3e-05 PS=1.24e-05
+ NRD=0.366667 NRS=0.533333
M4 OUT1 5 VDD VDD P L=8e-07 W=3.1e-06 AD=1.013e-11 AS=9.75e-12 PD=1.28e-05
+ PS=1.3e-05 NRD=0.387097 NRS=0.516129
M5 GROUND EN 4 GROUND N L=8e-07 W=2e-06 AD=7.76e-12 AS=8.41e-12 PD=1.14e-05
+ PS=1.19e-05 NRD=0.9 NRS=0.570968
M6 5 EN 6 GROUND N L=8e-07 W=2e-06 AD=7.76e-12 AS=7.76e-12 PD=1.14e-05
+ PS=1.14e-05 NRD=0.6 NRS=0.9
M7 6 IN1 GROUND GROUND N L=8e-07 W=2e-06 AD=9.41e-12 AS=7.76e-12 PD=1.29e-05
+ PS=1.14e-05 NRD=0.6 NRS=0.9
M8 GROUND 4 6 GROUND N L=8e-07 W=2e-06 AD=1.448e-11 AS=9.41e-12 PD=1.68e-05
+ PS=1.29e-05 NRD=0.533333 NRS=0.9
M9 OUT1 6 GROUND GROUND N L=8e-07 W=2e-06 AD=7.76e-12 AS=1.448e-11 PD=1.14e-05
+ PS=1.68e-05 NRD=0.6 NRS=0.9
.ends

.subckt TBUF01 EN IN1 OUT1 VDD GROUND
M0 VDD EN 4 VDD P L=8e-07 W=3e-06 AD=9e-12 AS=8.7e-12 PD=1.2e-05 PS=1.18e-05
+ NRD=0.383333 NRS=0.533333
M1 5 4 6 VDD P L=8e-07 W=3e-06 AD=8.7e-12 AS=9e-12 PD=1.18e-05 PS=1.2e-05
+ NRD=0.366667 NRS=0.533333
M2 5 IN1 VDD VDD P L=8e-07 W=4e-06 AD=1.28e-11 AS=1.2e-11 PD=1.44e-05 PS=1.4e-05
+ NRD=0.275 NRS=0.4
M3 VDD EN 5 VDD P L=8e-07 W=4e-06 AD=1.325e-11 AS=1.28e-11 PD=1.54e-05
+ PS=1.44e-05 NRD=0.275 NRS=0.4
M4 OUT1 5 VDD VDD P L=8e-07 W=4.3e-06 AD=1.385e-11 AS=1.325e-11 PD=1.52e-05
+ PS=1.54e-05 NRD=0.27907 NRS=0.372093
M5 GROUND EN 4 GROUND N L=8e-07 W=2e-06 AD=7.76e-12 AS=8.41e-12 PD=1.14e-05
+ PS=1.19e-05 NRD=0.9 NRS=0.570968
M6 5 EN 6 GROUND N L=8e-07 W=2e-06 AD=7.76e-12 AS=7.76e-12 PD=1.14e-05
+ PS=1.14e-05 NRD=0.6 NRS=0.9
M7 6 IN1 GROUND GROUND N L=8e-07 W=2e-06 AD=9.41e-12 AS=7.76e-12 PD=1.29e-05
+ PS=1.14e-05 NRD=0.6 NRS=0.9
M8 GROUND 4 6 GROUND N L=8e-07 W=2e-06 AD=1.463e-11 AS=9.41e-12 PD=1.68e-05
+ PS=1.29e-05 NRD=0.533333 NRS=0.9
M9 OUT1 6 GROUND GROUND N L=8e-07 W=2.3e-06 AD=7.91e-12 AS=1.463e-11 PD=1.14e-05
+ PS=1.68e-05 NRD=0.521739 NRS=0.782609
.ends

.subckt TINV00 EN OUT1 IN1 VDD GROUND
M0 VDD EN 5 VDD P L=8e-07 W=3e-06 AD=9.3e-12 AS=9.3e-12 PD=1.22e-05 PS=1.22e-05
+ NRD=0.4 NRS=0.6
M1 12 5 OUT1 VDD P L=8e-07 W=5.9e-06 AD=8.26e-12 AS=1.711e-11 PD=8.7e-06
+ PS=1.76e-05 NRD=0.237288 NRS=0.271186
M2 12 IN1 VDD VDD P L=8e-07 W=5.9e-06 AD=8.26e-12 AS=1.711e-11 PD=8.7e-06
+ PS=1.76e-05 NRD=0.237288 NRS=0.271186
M3 5 EN GROUND GROUND N L=8e-07 W=2e-06 AD=7.76e-12 AS=7.76e-12 PD=1.14e-05
+ PS=1.14e-05 NRD=0.6 NRS=0.9
M4 13 IN1 GROUND GROUND N L=8e-07 W=2.9e-06 AD=1.45e-12 AS=8.41e-12 PD=3.9e-06
+ PS=1.16e-05 NRD=0.172414 NRS=0.551724
M5 13 EN OUT1 GROUND N L=8e-07 W=2.9e-06 AD=1.45e-12 AS=8.41e-12 PD=3.9e-06
+ PS=1.16e-05 NRD=0.172414 NRS=0.551724
.ends

.subckt TINV01 EN OUT1 IN1 GROUND VDD
M0 VDD EN 4 VDD P L=8e-07 W=3e-06 AD=9.3e-12 AS=9.3e-12 PD=1.22e-05 PS=1.22e-05
+ NRD=0.4 NRS=0.6
M1 12 4 OUT1 VDD P L=8e-07 W=8.4e-06 AD=4.2e-12 AS=2.436e-11 PD=9.4e-06
+ PS=2.26e-05 NRD=0.0595238 NRS=0.190476
M2 VDD IN1 12 VDD P L=8e-07 W=8.4e-06 AD=2.436e-11 AS=4.2e-12 PD=2.26e-05
+ PS=9.4e-06 NRD=0.190476 NRS=0.0595238
M3 4 EN GROUND GROUND N L=8e-07 W=2e-06 AD=7.76e-12 AS=7.76e-12 PD=1.14e-05
+ PS=1.14e-05 NRD=0.6 NRS=0.9
M4 13 IN1 GROUND GROUND N L=8e-07 W=3.9e-06 AD=1.95e-12 AS=1.131e-11 PD=4.9e-06
+ PS=1.36e-05 NRD=0.128205 NRS=0.410256
M5 13 EN OUT1 GROUND N L=8e-07 W=3.9e-06 AD=1.95e-12 AS=1.131e-11 PD=4.9e-06
+ PS=1.36e-05 NRD=0.128205 NRS=0.410256
.ends

.subckt TRAN00 IN1 OUT1 EN GROUND VDD
M0 OUT1 6 IN1 VDD P L=8e-07 W=3e-06 AD=8.7e-12 AS=8.7e-12 PD=1.18e-05
+ PS=1.18e-05 NRD=0.366667 NRS=0.533333
M1 VDD EN 6 VDD P L=8e-07 W=3e-06 AD=8.7e-12 AS=8.7e-12 PD=1.18e-05 PS=1.18e-05
+ NRD=0.366667 NRS=0.533333
M2 OUT1 EN IN1 GROUND N L=8e-07 W=2e-06 AD=7.76e-12 AS=7.76e-12 PD=1.14e-05
+ PS=1.14e-05 NRD=0.6 NRS=0.9
M3 6 EN GROUND GROUND N L=8e-07 W=2e-06 AD=7.76e-12 AS=7.76e-12 PD=1.14e-05
+ PS=1.14e-05 NRD=0.6 NRS=0.9
.ends

.subckt XNR200 IN1 OUT1 IN2 GROUND VDD
M0 5 IN1 VDD VDD P L=8e-07 W=3e-06 AD=8.7e-12 AS=8.7e-12 PD=1.18e-05 PS=1.18e-05
+ NRD=0.366667 NRS=0.533333
M1 7 5 6 VDD P L=8e-07 W=3e-06 AD=1.05e-11 AS=8.7e-12 PD=1.3e-05 PS=1.18e-05
+ NRD=0.366667 NRS=0.533333
M2 2 IN1 7 VDD P L=8e-07 W=3e-06 AD=8.7e-12 AS=1.05e-11 PD=1.18e-05 PS=1.3e-05
+ NRD=0.366667 NRS=0.633333
M3 2 6 VDD VDD P L=8e-07 W=3e-06 AD=8.7e-12 AS=8.7e-12 PD=1.18e-05 PS=1.18e-05
+ NRD=0.366667 NRS=0.533333
M4 OUT1 7 VDD VDD P L=8e-07 W=3e-06 AD=8.7e-12 AS=8.7e-12 PD=1.18e-05
+ PS=1.18e-05 NRD=0.366667 NRS=0.533333
M5 VDD IN2 6 VDD P L=8e-07 W=3e-06 AD=8.7e-12 AS=8.7e-12 PD=1.18e-05 PS=1.18e-05
+ NRD=0.366667 NRS=0.533333
M6 5 IN1 GROUND GROUND N L=8e-07 W=2e-06 AD=7.76e-12 AS=7.76e-12 PD=1.14e-05
+ PS=1.14e-05 NRD=0.6 NRS=0.9
M7 7 IN1 6 GROUND N L=8e-07 W=2e-06 AD=8.76e-12 AS=7.76e-12 PD=1.24e-05
+ PS=1.14e-05 NRD=0.6 NRS=0.9
M8 2 5 7 GROUND N L=8e-07 W=2e-06 AD=7.76e-12 AS=8.76e-12 PD=1.14e-05
+ PS=1.24e-05 NRD=0.6 NRS=0.9
M9 2 6 GROUND GROUND N L=8e-07 W=2e-06 AD=7.76e-12 AS=7.76e-12 PD=1.14e-05
+ PS=1.14e-05 NRD=0.6 NRS=0.9
M10 OUT1 7 GROUND GROUND N L=8e-07 W=2e-06 AD=7.76e-12 AS=7.76e-12 PD=1.14e-05
+ PS=1.14e-05 NRD=0.6 NRS=0.9
M11 6 IN2 GROUND GROUND N L=8e-07 W=2e-06 AD=1.01e-11 AS=8.02e-12 PD=1.32e-05
+ PS=1.16e-05 NRD=0.475 NRS=0.925
.ends

.subckt XOR200 IN1 OUT1 IN2 GROUND VDD
M0 5 IN1 VDD VDD P L=8e-07 W=3e-06 AD=8.7e-12 AS=8.7e-12 PD=1.18e-05 PS=1.18e-05
+ NRD=0.366667 NRS=0.533333
M1 7 IN1 6 VDD P L=8e-07 W=3e-06 AD=1.05e-11 AS=8.7e-12 PD=1.3e-05 PS=1.18e-05
+ NRD=0.366667 NRS=0.533333
M2 2 5 7 VDD P L=8e-07 W=3e-06 AD=8.7e-12 AS=1.05e-11 PD=1.18e-05 PS=1.3e-05
+ NRD=0.366667 NRS=0.633333
M3 2 6 VDD VDD P L=8e-07 W=3e-06 AD=8.7e-12 AS=8.7e-12 PD=1.18e-05 PS=1.18e-05
+ NRD=0.366667 NRS=0.533333
M4 OUT1 7 VDD VDD P L=8e-07 W=3.1e-06 AD=8.99e-12 AS=8.99e-12 PD=1.2e-05
+ PS=1.2e-05 NRD=0.354839 NRS=0.516129
M5 VDD IN2 6 VDD P L=8e-07 W=3e-06 AD=8.7e-12 AS=8.7e-12 PD=1.18e-05 PS=1.18e-05
+ NRD=0.366667 NRS=0.533333
M6 5 IN1 GROUND GROUND N L=8e-07 W=2e-06 AD=7.76e-12 AS=7.76e-12 PD=1.14e-05
+ PS=1.14e-05 NRD=0.6 NRS=0.9
M7 7 5 6 GROUND N L=8e-07 W=2e-06 AD=8.76e-12 AS=7.76e-12 PD=1.24e-05
+ PS=1.14e-05 NRD=0.6 NRS=0.9
M8 2 IN1 7 GROUND N L=8e-07 W=2e-06 AD=7.76e-12 AS=8.76e-12 PD=1.14e-05
+ PS=1.24e-05 NRD=0.6 NRS=0.9
M9 2 6 GROUND GROUND N L=8e-07 W=2e-06 AD=7.76e-12 AS=7.76e-12 PD=1.14e-05
+ PS=1.14e-05 NRD=0.6 NRS=0.9
M10 OUT1 7 GROUND GROUND N L=8e-07 W=2e-06 AD=7.76e-12 AS=7.76e-12 PD=1.14e-05
+ PS=1.14e-05 NRD=0.6 NRS=0.9
M11 6 IN2 GROUND GROUND N L=8e-07 W=2e-06 AD=1.01e-11 AS=8.02e-12 PD=1.32e-05
+ PS=1.16e-05 NRD=0.475 NRS=0.925
.ends

.subckt XOR300 IN1 IN2 OUT1 IN3 GROUND VDD
M0 8 IN1 VDD VDD P L=8e-07 W=3e-06 AD=8.7e-12 AS=8.7e-12 PD=1.18e-05 PS=1.18e-05
+ NRD=0.366667 NRS=0.533333
M1 9 IN1 3 VDD P L=8e-07 W=3e-06 AD=1.05e-11 AS=8.7e-12 PD=1.3e-05 PS=1.18e-05
+ NRD=0.366667 NRS=0.533333
M2 2 8 9 VDD P L=8e-07 W=3e-06 AD=8.7e-12 AS=1.05e-11 PD=1.18e-05 PS=1.3e-05
+ NRD=0.366667 NRS=0.633333
M3 2 3 VDD VDD P L=8e-07 W=3e-06 AD=8.7e-12 AS=8.7e-12 PD=1.18e-05 PS=1.18e-05
+ NRD=0.366667 NRS=0.533333
M4 10 9 VDD VDD P L=8e-07 W=3.1e-06 AD=8.99e-12 AS=8.99e-12 PD=1.2e-05
+ PS=1.2e-05 NRD=0.354839 NRS=0.516129
M5 VDD IN2 3 VDD P L=8e-07 W=3e-06 AD=8.7e-12 AS=8.7e-12 PD=1.18e-05 PS=1.18e-05
+ NRD=0.366667 NRS=0.533333
M6 11 10 VDD VDD P L=8e-07 W=3e-06 AD=8.7e-12 AS=8.7e-12 PD=1.18e-05 PS=1.18e-05
+ NRD=0.366667 NRS=0.533333
M7 13 10 12 VDD P L=8e-07 W=3e-06 AD=1.05e-11 AS=8.7e-12 PD=1.3e-05 PS=1.18e-05
+ NRD=0.366667 NRS=0.533333
M8 5 11 13 VDD P L=8e-07 W=3e-06 AD=8.7e-12 AS=1.05e-11 PD=1.18e-05 PS=1.3e-05
+ NRD=0.366667 NRS=0.633333
M9 5 12 VDD VDD P L=8e-07 W=3e-06 AD=8.7e-12 AS=8.7e-12 PD=1.18e-05 PS=1.18e-05
+ NRD=0.366667 NRS=0.533333
M10 OUT1 13 VDD VDD P L=8e-07 W=3.1e-06 AD=8.99e-12 AS=8.99e-12 PD=1.2e-05
+ PS=1.2e-05 NRD=0.354839 NRS=0.516129
M11 VDD IN3 12 VDD P L=8e-07 W=3e-06 AD=8.7e-12 AS=8.7e-12 PD=1.18e-05
+ PS=1.18e-05 NRD=0.366667 NRS=0.533333
M12 8 IN1 GROUND GROUND N L=8e-07 W=2e-06 AD=7.76e-12 AS=7.76e-12 PD=1.14e-05
+ PS=1.14e-05 NRD=0.6 NRS=0.9
M13 9 8 3 GROUND N L=8e-07 W=2e-06 AD=8.76e-12 AS=7.76e-12 PD=1.24e-05
+ PS=1.14e-05 NRD=0.6 NRS=0.9
M14 2 IN1 9 GROUND N L=8e-07 W=2e-06 AD=7.76e-12 AS=8.76e-12 PD=1.14e-05
+ PS=1.24e-05 NRD=0.6 NRS=0.9
M15 2 3 GROUND GROUND N L=8e-07 W=2e-06 AD=7.76e-12 AS=7.76e-12 PD=1.14e-05
+ PS=1.14e-05 NRD=0.6 NRS=0.9
M16 10 9 GROUND GROUND N L=8e-07 W=2e-06 AD=7.76e-12 AS=7.76e-12 PD=1.14e-05
+ PS=1.14e-05 NRD=0.6 NRS=0.9
M17 3 IN2 GROUND GROUND N L=8e-07 W=2e-06 AD=1.01e-11 AS=8.02e-12 PD=1.32e-05
+ PS=1.16e-05 NRD=0.475 NRS=0.925
M18 11 10 GROUND GROUND N L=8e-07 W=2e-06 AD=7.76e-12 AS=7.76e-12 PD=1.14e-05
+ PS=1.14e-05 NRD=0.6 NRS=0.9
M19 13 11 12 GROUND N L=8e-07 W=2e-06 AD=8.76e-12 AS=7.76e-12 PD=1.24e-05
+ PS=1.14e-05 NRD=0.6 NRS=0.9
M20 5 10 13 GROUND N L=8e-07 W=2e-06 AD=7.76e-12 AS=8.76e-12 PD=1.14e-05
+ PS=1.24e-05 NRD=0.6 NRS=0.9
M21 5 12 GROUND GROUND N L=8e-07 W=2e-06 AD=7.76e-12 AS=7.76e-12 PD=1.14e-05
+ PS=1.14e-05 NRD=0.6 NRS=0.9
M22 OUT1 13 GROUND GROUND N L=8e-07 W=2e-06 AD=7.76e-12 AS=7.76e-12 PD=1.14e-05
+ PS=1.14e-05 NRD=0.6 NRS=0.9
M23 12 IN3 GROUND GROUND N L=8e-07 W=2e-06 AD=1.01e-11 AS=8.02e-12 PD=1.32e-05
+ PS=1.16e-05 NRD=0.475 NRS=0.925
.ends

.SUBCKT CAPSENSE_PHASE_GEN GROUND VDD CLK_1MHZ PHI1 PHI1B PHI2 PHI2B PHIT PHITB RST_N SAMPLE_VALID

X_050_ COUNT[2] _005_ GROUND VDD INVR00
X_051_ COUNT[1] _006_ GROUND VDD INVR00
X_052_ COUNT[0] NEXT_COUNT[0] GROUND VDD INVR00
X_053_ _004_ _007_ GROUND VDD INVR00
X_054_ COUNT[5] _008_ GROUND VDD INVR00
X_055_ COUNT[4] _009_ GROUND VDD INVR00
X_056_ COUNT[0] COUNT[1] _010_ GROUND VDD AND200
X_057_ _010_ COUNT[2] _011_ GROUND VDD NND200
X_058_ COUNT[0] COUNT[1] COUNT[2] COUNT[3] _012_ GROUND VDD NND400
X_059_ _004_ _012_ _013_ VDD GROUND NOR200
X_060_ _013_ COUNT[5] _014_ GROUND VDD OR2100
X_061_ COUNT[6] _009_ COUNT[5] _015_ GROUND VDD NND300
X_062_ COUNT[3] COUNT[2] _016_ VDD GROUND NOR200
X_063_ _016_ _010_ _017_ GROUND VDD NND200
X_064_ _017_ _015_ _018_ GROUND VDD OR2100
X_065_ _013_ COUNT[5] _019_ GROUND VDD NND200
X_066_ _019_ _018_ _014_ NEXT_COUNT[5] GROUND VDD AND300
X_067_ _010_ COUNT[2] _020_ GROUND VDD OR2100
X_068_ _018_ _011_ _021_ GROUND VDD NND200
X_069_ _020_ _018_ _011_ NEXT_COUNT[2] GROUND VDD AND300
X_070_ _007_ _022_ _012_ GROUND VDD XNR200
X_071_ _022_ _017_ _015_ _023_ GROUND VDD ORND00
X_072_ _023_ NEXT_COUNT[4] GROUND VDD INVR00
X_073_ COUNT[1] COUNT[0] _024_ VDD GROUND NOR200
X_074_ _010_ _024_ NEXT_COUNT[1] VDD GROUND NOR200
X_075_ COUNT[4] COUNT[5] _025_ GROUND VDD NND200
X_076_ _012_ _025_ _026_ VDD GROUND NOR200
X_077_ _026_ COUNT[6] _027_ GROUND VDD OR2100
X_078_ _026_ COUNT[6] _028_ GROUND VDD NND200
X_079_ _028_ _027_ _018_ _029_ GROUND VDD NND300
X_080_ _029_ NEXT_COUNT[6] GROUND VDD INVR00
X_081_ _011_ COUNT[3] _030_ GROUND VDD NND200
X_082_ _030_ _023_ _031_ GROUND VDD NND200
X_083_ _031_ NEXT_COUNT[5] NEXT_COUNT[6] _000_ VDD GROUND ADNR00
X_084_ _011_ COUNT[3] _032_ GROUND VDD OR2100
X_085_ _032_ _030_ NEXT_COUNT[3] GROUND VDD NND200
X_086_ COUNT[5] _023_ _033_ VDD GROUND NOR200
X_087_ _033_ _032_ NEXT_COUNT[6] _021_ _003_ GROUND VDD AND400
X_088_ _018_ _011_ _008_ _007_ COUNT[3] _034_ GROUND VDD AND500
X_089_ _034_ NEXT_COUNT[5] _035_ GROUND VDD OR2100
X_090_ NEXT_COUNT[0] _006_ _005_ COUNT[3] _036_ GROUND VDD AND400
X_091_ _036_ _033_ _029_ _037_ VDD GROUND ADNR00
X_092_ COUNT[2] COUNT[3] _038_ GROUND VDD NND200
X_093_ _023_ _038_ _010_ _039_ GROUND VDD ORND00
X_094_ _039_ NEXT_COUNT[5] _040_ GROUND VDD NND200
X_095_ _035_ _037_ _029_ _040_ _002_ VDD GROUND AOI400
X_096_ NEXT_COUNT[1] _020_ _011_ COUNT[3] _041_ GROUND VDD AND400
X_097_ NEXT_COUNT[5] _041_ NEXT_COUNT[4] _042_ GROUND VDD ORND00
X_098_ _035_ _037_ _029_ _042_ _001_ VDD GROUND AOI400
X_099_ CLKNET_1_1__LEAF_CLK_1MHZ _000_ RST_N PHI1B PHI1 GROUND VDD DFCL11
X_100_ CLKNET_1_1__LEAF_CLK_1MHZ _002_ RST_N PHITB PHIT GROUND VDD DFCL11
X_101_ CLKNET_1_1__LEAF_CLK_1MHZ _001_ RST_N PHI2B PHI2 GROUND VDD DFCL11
X_102_ CLKNET_1_1__LEAF_CLK_1MHZ _003_ RST_N _044_ SAMPLE_VALID GROUND VDD DFCL11
X_103_ CLKNET_1_0__LEAF_CLK_1MHZ NEXT_COUNT[0] RST_N _045_ COUNT[0] GROUND VDD DFPR11
X_104_ CLKNET_1_0__LEAF_CLK_1MHZ NEXT_COUNT[1] RST_N _046_ COUNT[1] GROUND VDD DFPR11
X_105_ CLKNET_1_0__LEAF_CLK_1MHZ NEXT_COUNT[2] RST_N _047_ COUNT[2] GROUND VDD DFCL11
X_106_ CLKNET_1_0__LEAF_CLK_1MHZ NEXT_COUNT[3] RST_N _048_ COUNT[3] GROUND VDD DFCL11
X_107_ CLKNET_1_0__LEAF_CLK_1MHZ NEXT_COUNT[4] RST_N _004_ COUNT[4] GROUND VDD DFCL11
X_108_ CLKNET_1_1__LEAF_CLK_1MHZ NEXT_COUNT[5] RST_N _049_ COUNT[5] GROUND VDD DFPR11
X_109_ CLKNET_1_1__LEAF_CLK_1MHZ NEXT_COUNT[6] RST_N _043_ COUNT[6] GROUND VDD DFPR11
XCLKBUF_0_CLK_1MHZ CLK_1MHZ CLKNET_0_CLK_1MHZ GROUND VDD BUFF00
XCLKBUF_1_0__F_CLK_1MHZ CLKNET_0_CLK_1MHZ CLKNET_1_0__LEAF_CLK_1MHZ GROUND VDD BUFF00
XCLKBUF_1_1__F_CLK_1MHZ CLKNET_0_CLK_1MHZ CLKNET_1_1__LEAF_CLK_1MHZ GROUND VDD BUFF00
XFILLER_0_0_0 GROUND VDD FILLER1
XFILLER_0_0_32 GROUND VDD FILLER1
XFILLER_0_0_64 GROUND VDD FILLER1
XFILLER_0_0_96 GROUND VDD FILLER1
XFILLER_0_0_128 GROUND VDD FILLER1
XFILLER_0_0_160 GROUND VDD FILLER1
XFILLER_0_0_192 GROUND VDD FILLER5
XFILLER_0_2_0 GROUND VDD FILLER1
XFILLER_0_2_32 GROUND VDD FILLER1
XFILLER_0_2_64 GROUND VDD FILLER1
XFILLER_0_2_96 GROUND VDD FILLER1
XFILLER_0_2_128 GROUND VDD FILLER1
XFILLER_0_2_160 GROUND VDD FILLER1
XFILLER_0_2_192 GROUND VDD FILLER5
XFILLER_0_4_0 GROUND VDD FILLER1
XFILLER_0_4_32 GROUND VDD FILLER1
XFILLER_0_4_64 GROUND VDD FILLER1
XFILLER_0_4_96 GROUND VDD FILLER1
XFILLER_0_4_128 GROUND VDD FILLER1
XFILLER_0_4_160 GROUND VDD FILLER1
XFILLER_0_4_192 GROUND VDD FILLER5
XFILLER_0_6_0 GROUND VDD FILLER1
XFILLER_0_6_32 GROUND VDD FILLER1
XFILLER_0_6_64 GROUND VDD FILLER1
XFILLER_0_6_96 GROUND VDD FILLER1
XFILLER_0_6_128 GROUND VDD FILLER1
XFILLER_0_6_160 GROUND VDD FILLER1
XFILLER_0_6_192 GROUND VDD FILLER5
XFILLER_0_8_0 GROUND VDD FILLER1
XFILLER_0_8_32 GROUND VDD FILLER1
XFILLER_0_8_64 GROUND VDD FILLER1
XFILLER_0_8_96 GROUND VDD FILLER3
XFILLER_0_8_104 GROUND VDD FILLER6
XFILLER_0_8_127 GROUND VDD FILLER1
XFILLER_0_8_159 GROUND VDD FILLER1
XFILLER_0_8_191 GROUND VDD FILLER5
XFILLER_0_8_193 GROUND VDD FILLER6
XFILLER_0_10_0 GROUND VDD FILLER1
XFILLER_0_10_32 GROUND VDD FILLER1
XFILLER_0_10_64 GROUND VDD FILLER5
XFILLER_0_10_66 GROUND VDD FILLER6
XFILLER_0_10_89 GROUND VDD FILLER2
XFILLER_0_10_105 GROUND VDD FILLER3
XFILLER_0_10_113 GROUND VDD FILLER6
XFILLER_0_10_123 GROUND VDD FILLER4
XFILLER_0_10_127 GROUND VDD FILLER5
XFILLER_0_10_129 GROUND VDD FILLER6
XFILLER_0_10_138 GROUND VDD FILLER3
XFILLER_0_10_146 GROUND VDD FILLER4
XFILLER_0_10_150 GROUND VDD FILLER5
XFILLER_0_10_152 GROUND VDD FILLER6
XFILLER_0_10_175 GROUND VDD FILLER2
XFILLER_0_10_191 GROUND VDD FILLER5
XFILLER_0_10_193 GROUND VDD FILLER6
XFILLER_0_12_0 GROUND VDD FILLER1
XFILLER_0_12_32 GROUND VDD FILLER4
XFILLER_0_12_36 GROUND VDD FILLER5
XFILLER_0_12_60 GROUND VDD FILLER2
XFILLER_0_12_76 GROUND VDD FILLER3
XFILLER_0_12_84 GROUND VDD FILLER4
XFILLER_0_12_95 GROUND VDD FILLER2
XFILLER_0_12_111 GROUND VDD FILLER5
XFILLER_0_12_117 GROUND VDD FILLER5
XFILLER_0_12_127 GROUND VDD FILLER3
XFILLER_0_12_135 GROUND VDD FILLER4
XFILLER_0_12_139 GROUND VDD FILLER6
XFILLER_0_12_147 GROUND VDD FILLER2
XFILLER_0_12_163 GROUND VDD FILLER5
XFILLER_0_12_165 GROUND VDD FILLER6
XFILLER_0_12_188 GROUND VDD FILLER4
XFILLER_0_12_192 GROUND VDD FILLER5
XFILLER_0_14_0 GROUND VDD FILLER1
XFILLER_0_14_32 GROUND VDD FILLER2
XFILLER_0_14_48 GROUND VDD FILLER4
XFILLER_0_14_52 GROUND VDD FILLER5
XFILLER_0_14_57 GROUND VDD FILLER3
XFILLER_0_14_65 GROUND VDD FILLER6
XFILLER_0_14_77 GROUND VDD FILLER2
XFILLER_0_14_93 GROUND VDD FILLER4
XFILLER_0_14_97 GROUND VDD FILLER6
XFILLER_0_14_102 GROUND VDD FILLER1
XFILLER_0_14_134 GROUND VDD FILLER1
XFILLER_0_14_166 GROUND VDD FILLER2
XFILLER_0_14_182 GROUND VDD FILLER3
XFILLER_0_14_190 GROUND VDD FILLER4
XFILLER_0_16_0 GROUND VDD FILLER1
XFILLER_0_16_32 GROUND VDD FILLER2
XFILLER_0_16_48 GROUND VDD FILLER3
XFILLER_0_16_56 GROUND VDD FILLER4
XFILLER_0_16_60 GROUND VDD FILLER6
XFILLER_0_16_64 GROUND VDD FILLER5
XFILLER_0_16_70 GROUND VDD FILLER3
XFILLER_0_16_78 GROUND VDD FILLER4
XFILLER_0_16_82 GROUND VDD FILLER6
XFILLER_0_16_96 GROUND VDD FILLER5
XFILLER_0_16_98 GROUND VDD FILLER6
XFILLER_0_16_109 GROUND VDD FILLER2
XFILLER_0_16_125 GROUND VDD FILLER5
XFILLER_0_16_127 GROUND VDD FILLER6
XFILLER_0_16_135 GROUND VDD FILLER2
XFILLER_0_16_151 GROUND VDD FILLER3
XFILLER_0_16_159 GROUND VDD FILLER4
XFILLER_0_16_163 GROUND VDD FILLER5
XFILLER_0_16_165 GROUND VDD FILLER6
XFILLER_0_16_188 GROUND VDD FILLER4
XFILLER_0_16_192 GROUND VDD FILLER5
XFILLER_0_18_0 GROUND VDD FILLER1
XFILLER_0_18_32 GROUND VDD FILLER5
XFILLER_0_18_56 GROUND VDD FILLER6
XFILLER_0_18_78 GROUND VDD FILLER5
XFILLER_0_18_88 GROUND VDD FILLER6
XFILLER_0_18_97 GROUND VDD FILLER3
XFILLER_0_18_114 GROUND VDD FILLER3
XFILLER_0_18_136 GROUND VDD FILLER6
XFILLER_0_18_153 GROUND VDD FILLER3
XFILLER_0_18_161 GROUND VDD FILLER4
XFILLER_0_18_165 GROUND VDD FILLER6
XFILLER_0_18_188 GROUND VDD FILLER4
XFILLER_0_18_192 GROUND VDD FILLER5
XFILLER_0_20_0 GROUND VDD FILLER1
XFILLER_0_20_32 GROUND VDD FILLER1
XFILLER_0_20_64 GROUND VDD FILLER1
XFILLER_0_20_96 GROUND VDD FILLER3
XFILLER_0_20_104 GROUND VDD FILLER5
XFILLER_0_20_106 GROUND VDD FILLER6
XFILLER_0_20_110 GROUND VDD FILLER2
XFILLER_0_20_126 GROUND VDD FILLER6
XFILLER_0_20_132 GROUND VDD FILLER1
XFILLER_0_20_164 GROUND VDD FILLER2
XFILLER_0_20_180 GROUND VDD FILLER3
XFILLER_0_20_188 GROUND VDD FILLER4
XFILLER_0_20_192 GROUND VDD FILLER5
XFILLER_0_22_0 GROUND VDD FILLER1
XFILLER_0_22_32 GROUND VDD FILLER1
XFILLER_0_22_64 GROUND VDD FILLER1
XFILLER_0_22_96 GROUND VDD FILLER2
XFILLER_0_22_112 GROUND VDD FILLER4
XFILLER_0_22_119 GROUND VDD FILLER2
XFILLER_0_22_135 GROUND VDD FILLER4
XFILLER_0_22_139 GROUND VDD FILLER5
XFILLER_0_22_144 GROUND VDD FILLER1
XFILLER_0_22_176 GROUND VDD FILLER2
XFILLER_0_22_192 GROUND VDD FILLER5
XFILLER_0_24_0 GROUND VDD FILLER1
XFILLER_0_24_32 GROUND VDD FILLER2
XFILLER_0_24_48 GROUND VDD FILLER4
XFILLER_0_24_52 GROUND VDD FILLER6
XFILLER_0_24_95 GROUND VDD FILLER5
XFILLER_0_24_108 GROUND VDD FILLER4
XFILLER_0_24_112 GROUND VDD FILLER6
XFILLER_0_24_117 GROUND VDD FILLER5
XFILLER_0_24_132 GROUND VDD FILLER4
XFILLER_0_24_136 GROUND VDD FILLER5
XFILLER_0_24_138 GROUND VDD FILLER6
XFILLER_0_24_183 GROUND VDD FILLER3
XFILLER_0_24_191 GROUND VDD FILLER5
XFILLER_0_24_193 GROUND VDD FILLER6
XFILLER_0_26_0 GROUND VDD FILLER1
XFILLER_0_26_32 GROUND VDD FILLER1
XFILLER_0_26_64 GROUND VDD FILLER2
XFILLER_0_26_80 GROUND VDD FILLER4
XFILLER_0_26_88 GROUND VDD FILLER6
XFILLER_0_26_92 GROUND VDD FILLER5
XFILLER_0_26_94 GROUND VDD FILLER6
XFILLER_0_26_103 GROUND VDD FILLER3
XFILLER_0_26_125 GROUND VDD FILLER1
XFILLER_0_26_157 GROUND VDD FILLER1
XFILLER_0_26_189 GROUND VDD FILLER4
XFILLER_0_26_193 GROUND VDD FILLER6
XFILLER_0_28_0 GROUND VDD FILLER1
XFILLER_0_28_32 GROUND VDD FILLER1
XFILLER_0_28_64 GROUND VDD FILLER1
XFILLER_0_28_96 GROUND VDD FILLER1
XFILLER_0_28_128 GROUND VDD FILLER1
XFILLER_0_28_160 GROUND VDD FILLER1
XFILLER_0_28_192 GROUND VDD FILLER5

.ENDS CAPSENSE_PHASE_GEN

.subckt capsense_current_ota INP INN OUTP OUTM VDD VSS IREF VCM VBN VBP
M1000 VDD OUTM A_166200_473000# VSS N W=20.0u L=1.6u
M1001 OUTP A_163000_528900# OUTP OUTP P W=20.0u L=10.0u
M1002 OUTP A_163000_528900# OUTP OUTP P W=20.0u L=10.0u
M1003 A_163000_868700# IREF VSS VSS N W=11.43u L=3.2u
M1004 OUTP A_163000_528900# OUTP OUTP P W=20.0u L=10.0u
M1006 A_200200_868700# A_200200_868700# VSS VSS N W=10.0u L=3.2u
M1007 A_239000_71400# INN A_166200_71400# VSS N W=15.0u L=2.4u
M1008 A_158500_217600# A_163000_528900# VDD VDD P W=40.0u L=3.2u
M1009 OUTM A_163000_528900# OUTM OUTM P W=20.0u L=10.0u
M1010 OUTP A_163000_528900# OUTP OUTP P W=20.0u L=10.0u
M1011 OUTM A_163000_528900# OUTM OUTM P W=20.0u L=10.0u
M1012 OUTM A_163000_528900# OUTM OUTM P W=20.0u L=10.0u
M1013 OUTM A_163000_528900# OUTM OUTM P W=20.0u L=10.0u
M1014 A_274600_868700# A_274600_868700# VSS VSS N W=10.0u L=3.2u
M1015 OUTP VBN A_239000_71400# VSS N W=30.0u L=2.4u
M1018 VDD OUTP A_158500_329400# VSS N W=20.0u L=1.6u
M1019 A_163000_916100# A_163000_916100# VDD VDD P W=10.0u L=3.2u
M1021 OUTP A_163000_528900# OUTP OUTP P W=20.0u L=10.0u
M1022 OUTP A_163000_528900# OUTP OUTP P W=20.0u L=10.0u
M1023 VDD VCM A_158500_401200# VSS N W=20.0u L=1.6u
M1025 OUTP A_163000_528900# OUTP OUTP P W=20.0u L=10.0u
M1026 A_166200_473000# IREF VSS VSS N W=20.0u L=3.2u
M1027 A_163000_528900# A_200200_868700# VSS VSS N W=10.0u L=3.2u
M1028 A_200200_868700# A_161400_1209400# A_166200_870200# VDD P W=5.0u L=2.4u
M1032 A_163000_916100# A_274600_868700# VSS VSS N W=10.0u L=3.2u
M1033 OUTM VBN A_202600_71400# VSS N W=30.0u L=2.4u
M1034 A_158500_329400# IREF VSS VSS N W=20.0u L=3.2u
M1036 VDD VCM A_158500_401200# VSS N W=20.0u L=1.6u
M1039 A_166200_71400# IREF VSS VSS N W=80.0u L=3.2u
M1040 A_158500_401200# IREF VSS VSS N W=20.0u L=3.2u
M1041 OUTP VBP A_158500_217600# VDD P W=60.0u L=2.4u
M1042 OUTM VBP A_202600_217600# VDD P W=60.0u L=2.4u
M1043 A_163000_868700# A_163000_868700# VDD VDD P W=20.0u L=3.2u
M1044 A_166200_870200# A_163000_868700# VDD VDD P W=10.0u L=3.2u
M1045 A_202600_217600# A_163000_528900# VDD VDD P W=40.0u L=3.2u
M1046 OUTM A_163000_528900# OUTM OUTM P W=20.0u L=10.0u
M1047 OUTM A_163000_528900# OUTM OUTM P W=20.0u L=10.0u
M1049 OUTM A_163000_528900# OUTM OUTM P W=20.0u L=10.0u
M1050 OUTM A_163000_528900# OUTM OUTM P W=20.0u L=10.0u
M1051 OUTM A_163000_528900# OUTM OUTM P W=20.0u L=10.0u
M1052 OUTP A_163000_528900# OUTP OUTP P W=20.0u L=10.0u
M1053 IREF IREF VSS VSS N W=20.0u L=3.2u
M1054 OUTP A_163000_528900# OUTP OUTP P W=20.0u L=10.0u
M1055 OUTM A_163000_528900# OUTM OUTM P W=20.0u L=10.0u
M1056 OUTP A_163000_528900# OUTP OUTP P W=20.0u L=10.0u
M1057 OUTM A_163000_528900# OUTM OUTM P W=20.0u L=10.0u
M1058 OUTP A_163000_528900# OUTP OUTP P W=20.0u L=10.0u
M1059 A_202600_71400# INP A_166200_71400# VSS N W=15.0u L=2.4u
M1060 OUTM A_163000_528900# OUTM OUTM P W=20.0u L=10.0u
M1061 OUTP A_163000_528900# OUTP OUTP P W=20.0u L=10.0u
M1062 A_274600_868700# A_158500_401200# A_166200_870200# VDD P W=5.0u L=2.4u
M1063 A_163000_528900# A_163000_916100# VDD VDD P W=10.0u L=3.2u
M1064 VDD OUTM A_166200_473000# VSS N W=20.0u L=1.6u
M1065 VDD OUTP A_158500_329400# VSS N W=20.0u L=1.6u
MVCRPN A_158500_329400# VDD A_161400_1209400# VSS N W=2.5u L=51.22u
MVCRMN A_166200_473000# VDD A_161400_1209400# VSS N W=2.5u L=51.22u
.ends capsense_current_ota

.subckt OTA INP INN OUTP OUTM VDD VSS IREF VCM VBN VBP
XCORE INP INN OUTP OUTM VDD VSS IREF VCM VBN VBP capsense_current_ota
.ends OTA

.subckt capsense_current_sc VDD VSS VEXC SENSP SENSN TXP TXN RXP RXN SUMP SUMN OUTP OUTN PHI1 PHI1B PHIT PHITB PHI2 PHI2B
MSENSEPN SENSP PHI2 TXP VSS N W=2.5u L=0.8u
MSENSEPP SENSP PHI2B TXP VDD P W=4.5u L=0.8u
MSRESETPN SENSP PHI1 VSS VSS N W=2.5u L=0.8u
MSRESETPP SENSP PHI1B VSS VDD P W=4.5u L=0.8u
MCHARGEPN VEXC PHI1 TXP VSS N W=2.5u L=0.8u
MCHARGEPP VEXC PHI1B TXP VDD P W=4.5u L=0.8u
MRRESETPN RXP PHI1 VSS VSS N W=2.5u L=0.8u
MRRESETPP RXP PHI1B VSS VDD P W=4.5u L=0.8u
MXFERPN RXP PHIT SUMP VSS N W=2.5u L=0.8u
MXFERPP RXP PHITB SUMP VDD P W=4.5u L=0.8u
MFBRESETPN SUMP PHI1 OUTP VSS N W=2.5u L=0.8u
MFBRESETPP SUMP PHI1B OUTP VDD P W=4.5u L=0.8u
MCSP0 TXP RXP TXP TXP P W=20u L=25.34u
MCFP0 SUMP OUTP SUMP SUMP P W=20u L=38.005u
MCSP1 TXP RXP TXP TXP P W=20u L=25.34u
MCFP1 SUMP OUTP SUMP SUMP P W=20u L=38.005u
MCSP2 TXP RXP TXP TXP P W=20u L=25.34u
MCFP2 SUMP OUTP SUMP SUMP P W=20u L=38.005u
MCSP3 TXP RXP TXP TXP P W=20u L=25.34u
MCFP3 SUMP OUTP SUMP SUMP P W=20u L=38.005u
MCSP4 TXP RXP TXP TXP P W=20u L=25.34u
MCFP4 SUMP OUTP SUMP SUMP P W=20u L=38.005u
MSENSENN SENSN PHI2 TXN VSS N W=2.5u L=0.8u
MSENSENP SENSN PHI2B TXN VDD P W=4.5u L=0.8u
MSRESETNN SENSN PHI1 VSS VSS N W=2.5u L=0.8u
MSRESETNP SENSN PHI1B VSS VDD P W=4.5u L=0.8u
MCHARGENN VEXC PHI1 TXN VSS N W=2.5u L=0.8u
MCHARGENP VEXC PHI1B TXN VDD P W=4.5u L=0.8u
MRRESETNN RXN PHI1 VSS VSS N W=2.5u L=0.8u
MRRESETNP RXN PHI1B VSS VDD P W=4.5u L=0.8u
MXFERNN RXN PHIT SUMN VSS N W=2.5u L=0.8u
MXFERNP RXN PHITB SUMN VDD P W=4.5u L=0.8u
MFBRESETNN SUMN PHI1 OUTN VSS N W=2.5u L=0.8u
MFBRESETNP SUMN PHI1B OUTN VDD P W=4.5u L=0.8u
MCSN0 TXN RXN TXN TXN P W=20u L=25.34u
MCFN0 SUMN OUTN SUMN SUMN P W=20u L=38.005u
MCSN1 TXN RXN TXN TXN P W=20u L=25.34u
MCFN1 SUMN OUTN SUMN SUMN P W=20u L=38.005u
MCSN2 TXN RXN TXN TXN P W=20u L=25.34u
MCFN2 SUMN OUTN SUMN SUMN P W=20u L=38.005u
MCSN3 TXN RXN TXN TXN P W=20u L=25.34u
MCFN3 SUMN OUTN SUMN SUMN P W=20u L=38.005u
MCSN4 TXN RXN TXN TXN P W=20u L=25.34u
MCFN4 SUMN OUTN SUMN SUMN P W=20u L=38.005u
MCN0 VSS SENSN VSS VSS P W=20u L=60.81u
MCN1 VSS SENSN VSS VSS P W=20u L=60.81u
MCN2 VSS SENSN VSS VSS P W=20u L=60.81u
MCN3 VSS SENSN VSS VSS P W=20u L=60.81u
MCN4 VSS SENSN VSS VSS P W=20u L=60.81u
.ends capsense_current_sc

.subckt Switch_cap VDD VSS VEXC SENSP SENSN TXP TXN RXP RXN SUMP SUMN OUTP OUTN PHI1 PHI1B PHIT PHITB PHI2 PHI2B
XCORE VDD VSS VEXC SENSP SENSN TXP TXN RXP RXN SUMP SUMN OUTP OUTN PHI1 PHI1B PHIT PHITB PHI2 PHI2B capsense_current_sc
.ends Switch_cap

.subckt capsense_controller_mos SUMP SUMN VDD VSS VREF PHI1 PHIT PHI2 CLK_1MHZ SAMPLE_VALID RST_N XTIMING_XFF1_11 XTIMING_XFF1_12 XTIMING_XFF1_3 XTIMING_XFF1_4 XTIMING_XFF1_6 XTIMING_XFF1_7 XTIMING_XFF1_8 XTIMING_XFF1_13 XTIMING_UNUSED_QB1 XTIMING_DELAY1 XTIMING_XFF1_29 XTIMING_XFF1_30 XTIMING_XFF2_11 XTIMING_XFF2_12 XTIMING_XFF2_3 XTIMING_XFF2_4 XTIMING_XFF2_6 XTIMING_XFF2_7 XTIMING_XFF2_8 XTIMING_XFF2_13 XTIMING_UNUSED_QB2 XTIMING_DELAY2 XTIMING_XFF2_29 XTIMING_XFF2_30 XTIMING_EN_B SAMPLE_EN XCORE_SENSE XCORE_SAMPLE_B XCORE_XSAMPLE_EB XCORE_VINT XCORE_ERROR_OUT XCORE_XDUMP_EB XCORE_XHOLD_EB XCORE_CM_HOLD XCORE_RESET_ACTIVE XCORE_XINIT_EB XCORE_XINITH_EB XCORE_RESET_BAR XCORE_RESET_ALL XCORE_E1 XCORE_E1B XCORE_E2 XCORE_E2B XCORE_PRE_B XCORE_XPREN_SERIES_NODE XCORE_PRE XCORE_XCOMMANDBUF_DISABLED XCORE_XCOMMANDBUF_XR_EB XCORE_HELD_BUFFER XCORE_XTOP_EB XCORE_RT XCORE_XBOTTOM_EB XCORE_RB XCORE_XBYPASS_EB XCORE_MIX XCORE_XMIXRESET_EB XCORE_XOUTRESET_EB XCORE_CM_X XTIMING_XN_SERIES_NODE XCORE_NB XCORE_PB XCORE_XRN_SERIES_NODE XCORE_XL1_XQ_SERIES_NODE XCORE_XL1_XQB_SERIES_NODE XCORE_XL2_XQ_SERIES_NODE XCORE_XL2_XQB_SERIES_NODE XCORE_XCOMMANDBUF_BT XCORE_XCOMMANDBUF_BL XCORE_XCOMMANDBUF_GAIN XCORE_BT XCORE_BL XCORE_GAIN XCORE_XCOMMANDBUF_LP XCORE_LP XCORE_LEFT XCORE_PCAS XCORE_ERR_LEFT XCORE_ERR_RIGHT XCORE_TAIL
MXTIMING_XFF1_M0_0 VDD CLK_1MHZ XTIMING_XFF1_11 VDD P W=3.0u L=0.8u
MXTIMING_XFF1_M1_0 XTIMING_XFF1_12 XTIMING_XFF1_11 VDD VDD P W=3.0u L=0.8u
MXTIMING_XFF1_M2_0 XTIMING_XFF1_3 XTIMING_XFF1_12 SAMPLE_VALID VDD P W=3.0u L=0.8u
MXTIMING_XFF1_M3_0 XTIMING_XFF1_4 XTIMING_XFF1_11 XTIMING_XFF1_3 VDD P W=3.0u L=0.8u
MXTIMING_XFF1_M4_0 VDD XTIMING_XFF1_6 XTIMING_XFF1_4 VDD P W=3.0u L=0.8u
MXTIMING_XFF1_M5_0 VDD RST_N XTIMING_XFF1_6 VDD P W=3.0u L=0.8u
MXTIMING_XFF1_M6_0 XTIMING_XFF1_6 XTIMING_XFF1_3 VDD VDD P W=3.0u L=0.8u
MXTIMING_XFF1_M7_0 XTIMING_XFF1_7 XTIMING_XFF1_11 XTIMING_XFF1_6 VDD P W=3.0u L=0.8u
MXTIMING_XFF1_M8_0 XTIMING_XFF1_8 XTIMING_XFF1_12 XTIMING_XFF1_7 VDD P W=3.0u L=0.8u
MXTIMING_XFF1_M9_0 VDD XTIMING_XFF1_13 XTIMING_XFF1_8 VDD P W=3.0u L=0.8u
MXTIMING_XFF1_M10_0 XTIMING_XFF1_8 RST_N VDD VDD P W=3.0u L=0.8u
MXTIMING_XFF1_M11_0 XTIMING_XFF1_13 XTIMING_XFF1_7 VDD VDD P W=3.0u L=0.8u
MXTIMING_XFF1_M12_0 VDD XTIMING_XFF1_13 XTIMING_UNUSED_QB1 VDD P W=4.4u L=0.8u
MXTIMING_XFF1_M13_0 XTIMING_DELAY1 XTIMING_UNUSED_QB1 VDD VDD P W=4.6000000000000005u L=0.8u
MXTIMING_XFF1_M14_0 VSS CLK_1MHZ XTIMING_XFF1_11 VSS N W=2.0u L=0.8u
MXTIMING_XFF1_M15_0 XTIMING_XFF1_12 XTIMING_XFF1_11 VSS VSS N W=2.0u L=0.8u
MXTIMING_XFF1_M16_0 XTIMING_XFF1_3 XTIMING_XFF1_11 SAMPLE_VALID VSS N W=2.0u L=0.8u
MXTIMING_XFF1_M17_0 XTIMING_XFF1_4 XTIMING_XFF1_12 XTIMING_XFF1_3 VSS N W=2.0u L=0.8u
MXTIMING_XFF1_M18_0 VSS XTIMING_XFF1_6 XTIMING_XFF1_4 VSS N W=2.0u L=0.8u
MXTIMING_XFF1_M19_0 XTIMING_XFF1_29 RST_N VSS VSS N W=2.0u L=0.8u
MXTIMING_XFF1_M20_0 XTIMING_XFF1_6 XTIMING_XFF1_3 XTIMING_XFF1_29 VSS N W=2.0u L=0.8u
MXTIMING_XFF1_M21_0 XTIMING_XFF1_7 XTIMING_XFF1_12 XTIMING_XFF1_6 VSS N W=2.0u L=0.8u
MXTIMING_XFF1_M22_0 XTIMING_XFF1_8 XTIMING_XFF1_11 XTIMING_XFF1_7 VSS N W=2.0u L=0.8u
MXTIMING_XFF1_M23_0 XTIMING_XFF1_30 XTIMING_XFF1_13 XTIMING_XFF1_8 VSS N W=2.0u L=0.8u
MXTIMING_XFF1_M24_0 VSS RST_N XTIMING_XFF1_30 VSS N W=2.0u L=0.8u
MXTIMING_XFF1_M25_0 XTIMING_XFF1_13 XTIMING_XFF1_7 VSS VSS N W=2.0u L=0.8u
MXTIMING_XFF1_M26_0 VSS XTIMING_XFF1_13 XTIMING_UNUSED_QB1 VSS N W=2.4u L=0.8u
MXTIMING_XFF1_M27_0 XTIMING_DELAY1 XTIMING_UNUSED_QB1 VSS VSS N W=2.4u L=0.8u
MXTIMING_XFF2_M0_0 VDD CLK_1MHZ XTIMING_XFF2_11 VDD P W=3.0u L=0.8u
MXTIMING_XFF2_M1_0 XTIMING_XFF2_12 XTIMING_XFF2_11 VDD VDD P W=3.0u L=0.8u
MXTIMING_XFF2_M2_0 XTIMING_XFF2_3 XTIMING_XFF2_12 XTIMING_DELAY1 VDD P W=3.0u L=0.8u
MXTIMING_XFF2_M3_0 XTIMING_XFF2_4 XTIMING_XFF2_11 XTIMING_XFF2_3 VDD P W=3.0u L=0.8u
MXTIMING_XFF2_M4_0 VDD XTIMING_XFF2_6 XTIMING_XFF2_4 VDD P W=3.0u L=0.8u
MXTIMING_XFF2_M5_0 VDD RST_N XTIMING_XFF2_6 VDD P W=3.0u L=0.8u
MXTIMING_XFF2_M6_0 XTIMING_XFF2_6 XTIMING_XFF2_3 VDD VDD P W=3.0u L=0.8u
MXTIMING_XFF2_M7_0 XTIMING_XFF2_7 XTIMING_XFF2_11 XTIMING_XFF2_6 VDD P W=3.0u L=0.8u
MXTIMING_XFF2_M8_0 XTIMING_XFF2_8 XTIMING_XFF2_12 XTIMING_XFF2_7 VDD P W=3.0u L=0.8u
MXTIMING_XFF2_M9_0 VDD XTIMING_XFF2_13 XTIMING_XFF2_8 VDD P W=3.0u L=0.8u
MXTIMING_XFF2_M10_0 XTIMING_XFF2_8 RST_N VDD VDD P W=3.0u L=0.8u
MXTIMING_XFF2_M11_0 XTIMING_XFF2_13 XTIMING_XFF2_7 VDD VDD P W=3.0u L=0.8u
MXTIMING_XFF2_M12_0 VDD XTIMING_XFF2_13 XTIMING_UNUSED_QB2 VDD P W=4.4u L=0.8u
MXTIMING_XFF2_M13_0 XTIMING_DELAY2 XTIMING_UNUSED_QB2 VDD VDD P W=4.6000000000000005u L=0.8u
MXTIMING_XFF2_M14_0 VSS CLK_1MHZ XTIMING_XFF2_11 VSS N W=2.0u L=0.8u
MXTIMING_XFF2_M15_0 XTIMING_XFF2_12 XTIMING_XFF2_11 VSS VSS N W=2.0u L=0.8u
MXTIMING_XFF2_M16_0 XTIMING_XFF2_3 XTIMING_XFF2_11 XTIMING_DELAY1 VSS N W=2.0u L=0.8u
MXTIMING_XFF2_M17_0 XTIMING_XFF2_4 XTIMING_XFF2_12 XTIMING_XFF2_3 VSS N W=2.0u L=0.8u
MXTIMING_XFF2_M18_0 VSS XTIMING_XFF2_6 XTIMING_XFF2_4 VSS N W=2.0u L=0.8u
MXTIMING_XFF2_M19_0 XTIMING_XFF2_29 RST_N VSS VSS N W=2.0u L=0.8u
MXTIMING_XFF2_M20_0 XTIMING_XFF2_6 XTIMING_XFF2_3 XTIMING_XFF2_29 VSS N W=2.0u L=0.8u
MXTIMING_XFF2_M21_0 XTIMING_XFF2_7 XTIMING_XFF2_12 XTIMING_XFF2_6 VSS N W=2.0u L=0.8u
MXTIMING_XFF2_M22_0 XTIMING_XFF2_8 XTIMING_XFF2_11 XTIMING_XFF2_7 VSS N W=2.0u L=0.8u
MXTIMING_XFF2_M23_0 XTIMING_XFF2_30 XTIMING_XFF2_13 XTIMING_XFF2_8 VSS N W=2.0u L=0.8u
MXTIMING_XFF2_M24_0 VSS RST_N XTIMING_XFF2_30 VSS N W=2.0u L=0.8u
MXTIMING_XFF2_M25_0 XTIMING_XFF2_13 XTIMING_XFF2_7 VSS VSS N W=2.0u L=0.8u
MXTIMING_XFF2_M26_0 VSS XTIMING_XFF2_13 XTIMING_UNUSED_QB2 VSS N W=2.4u L=0.8u
MXTIMING_XFF2_M27_0 XTIMING_DELAY2 XTIMING_UNUSED_QB2 VSS VSS N W=2.4u L=0.8u
MXTIMING_XN_MN1_0 XTIMING_EN_B XTIMING_DELAY1 VSS VSS N W=2.5u L=0.8u
MXTIMING_XN_MN2_0 XTIMING_EN_B XTIMING_DELAY2 VSS VSS N W=2.5u L=0.8u
MXTIMING_XI_MN_0 SAMPLE_EN XTIMING_EN_B VSS VSS N W=2.5u L=0.8u
MXTIMING_XI_MP_0 SAMPLE_EN XTIMING_EN_B VDD VDD P W=4.5u L=0.8u
MXCORE_MAVG_P_0 SUMP VDD XCORE_SENSE VSS N W=2.5u L=50.0u
MXCORE_MAVG_N_0 SUMN VDD XCORE_SENSE VSS N W=2.5u L=50.0u
MXCORE_XSE_MN_0 XCORE_SAMPLE_B SAMPLE_EN VSS VSS N W=2.5u L=0.8u
MXCORE_XSE_MP_0 XCORE_SAMPLE_B SAMPLE_EN VDD VDD P W=4.5u L=0.8u
MXCORE_XSAMPLE_XI_MN_0 XCORE_XSAMPLE_EB SAMPLE_EN VSS VSS N W=2.5u L=0.8u
MXCORE_XSAMPLE_XI_MP_0 XCORE_XSAMPLE_EB SAMPLE_EN VDD VDD P W=4.5u L=0.8u
MXCORE_XSAMPLE_XT_MM1_0 XCORE_VINT SAMPLE_EN XCORE_ERROR_OUT VSS N W=2.5u L=0.8u
MXCORE_XSAMPLE_XT_MM2_0 XCORE_VINT XCORE_XSAMPLE_EB XCORE_ERROR_OUT VDD P W=4.5u L=0.8u
MXCORE_XDUMP_XI_MN_0 XCORE_XDUMP_EB XCORE_SAMPLE_B VSS VSS N W=2.5u L=0.8u
MXCORE_XDUMP_XI_MP_0 XCORE_XDUMP_EB XCORE_SAMPLE_B VDD VDD P W=4.5u L=0.8u
MXCORE_XDUMP_XT_MM1_0 VREF XCORE_SAMPLE_B XCORE_ERROR_OUT VSS N W=2.5u L=0.8u
MXCORE_XDUMP_XT_MM2_0 VREF XCORE_XDUMP_EB XCORE_ERROR_OUT VDD P W=4.5u L=0.8u
MXCORE_XHOLD_XI_MN_0 XCORE_XHOLD_EB PHI1 VSS VSS N W=2.5u L=0.8u
MXCORE_XHOLD_XI_MP_0 XCORE_XHOLD_EB PHI1 VDD VDD P W=4.5u L=0.8u
MXCORE_XHOLD_XT_MM1_0 XCORE_CM_HOLD PHI1 XCORE_VINT VSS N W=2.5u L=0.8u
MXCORE_XHOLD_XT_MM2_0 XCORE_CM_HOLD XCORE_XHOLD_EB XCORE_VINT VDD P W=4.5u L=0.8u
MXCORE_XRINV_MN_0 XCORE_RESET_ACTIVE RST_N VSS VSS N W=2.5u L=0.8u
MXCORE_XRINV_MP_0 XCORE_RESET_ACTIVE RST_N VDD VDD P W=4.5u L=0.8u
MXCORE_XINIT_XI_MN_0 XCORE_XINIT_EB XCORE_RESET_ACTIVE VSS VSS N W=2.5u L=0.8u
MXCORE_XINIT_XI_MP_0 XCORE_XINIT_EB XCORE_RESET_ACTIVE VDD VDD P W=4.5u L=0.8u
MXCORE_XINIT_XT_MM1_0 VREF XCORE_RESET_ACTIVE XCORE_VINT VSS N W=2.5u L=0.8u
MXCORE_XINIT_XT_MM2_0 VREF XCORE_XINIT_EB XCORE_VINT VDD P W=4.5u L=0.8u
MXCORE_XINITH_XI_MN_0 XCORE_XINITH_EB XCORE_RESET_ACTIVE VSS VSS N W=2.5u L=0.8u
MXCORE_XINITH_XI_MP_0 XCORE_XINITH_EB XCORE_RESET_ACTIVE VDD VDD P W=4.5u L=0.8u
MXCORE_XINITH_XT_MM1_0 VREF XCORE_RESET_ACTIVE XCORE_CM_HOLD VSS N W=2.5u L=0.8u
MXCORE_XINITH_XT_MM2_0 VREF XCORE_XINITH_EB XCORE_CM_HOLD VDD P W=4.5u L=0.8u
MXCORE_XRN_MN1_0 XCORE_RESET_BAR PHI1 VSS VSS N W=2.5u L=0.8u
MXCORE_XRN_MN2_0 XCORE_RESET_BAR XCORE_RESET_ACTIVE VSS VSS N W=2.5u L=0.8u
MXCORE_XRI_MN_0 XCORE_RESET_ALL XCORE_RESET_BAR VSS VSS N W=2.5u L=0.8u
MXCORE_XRI_MP_0 XCORE_RESET_ALL XCORE_RESET_BAR VDD VDD P W=4.5u L=0.8u
MXCORE_XL1_XQ_MN1_0 XCORE_E1 XCORE_RESET_ALL VSS VSS N W=2.5u L=0.8u
MXCORE_XL1_XQ_MN2_0 XCORE_E1 XCORE_E1B VSS VSS N W=2.5u L=0.8u
MXCORE_XL1_XQB_MN1_0 XCORE_E1B PHIT VSS VSS N W=2.5u L=0.8u
MXCORE_XL1_XQB_MN2_0 XCORE_E1B XCORE_E1 VSS VSS N W=2.5u L=0.8u
MXCORE_XL2_XQ_MN1_0 XCORE_E2 XCORE_RESET_ALL VSS VSS N W=2.5u L=0.8u
MXCORE_XL2_XQ_MN2_0 XCORE_E2 XCORE_E2B VSS VSS N W=2.5u L=0.8u
MXCORE_XL2_XQB_MN1_0 XCORE_E2B PHI2 VSS VSS N W=2.5u L=0.8u
MXCORE_XL2_XQB_MN2_0 XCORE_E2B XCORE_E2 VSS VSS N W=2.5u L=0.8u
MXCORE_XPREN_MP1_0 XCORE_PRE_B XCORE_E1 VDD VDD P W=4.5u L=0.8u
MXCORE_XPREN_MP2_0 XCORE_PRE_B XCORE_E2B VDD VDD P W=4.5u L=0.8u
MXCORE_XPREN_MN1_0 XCORE_PRE_B XCORE_E1 XCORE_XPREN_SERIES_NODE VSS N W=5.0u L=0.8u
MXCORE_XPREN_MN2_0 XCORE_XPREN_SERIES_NODE XCORE_E2B VSS VSS N W=5.0u L=0.8u
MXCORE_XPREI_MN_0 XCORE_PRE XCORE_PRE_B VSS VSS N W=2.5u L=0.8u
MXCORE_XPREI_MP_0 XCORE_PRE XCORE_PRE_B VDD VDD P W=4.5u L=0.8u
MXCORE_XCOMMANDBUF_XI_MN_0 XCORE_XCOMMANDBUF_DISABLED XCORE_E1 VSS VSS N W=2.5u L=0.8u
MXCORE_XCOMMANDBUF_XI_MP_0 XCORE_XCOMMANDBUF_DISABLED XCORE_E1 VDD VDD P W=4.5u L=0.8u
MXCORE_XCOMMANDBUF_XR_XI_MN_0 XCORE_XCOMMANDBUF_XR_EB XCORE_XCOMMANDBUF_DISABLED VSS VSS N W=2.5u L=0.8u
MXCORE_XCOMMANDBUF_XR_XI_MP_0 XCORE_XCOMMANDBUF_XR_EB XCORE_XCOMMANDBUF_DISABLED VDD VDD P W=4.5u L=0.8u
MXCORE_XCOMMANDBUF_XR_XT_MM1_0 VSS XCORE_XCOMMANDBUF_DISABLED XCORE_HELD_BUFFER VSS N W=2.5u L=0.8u
MXCORE_XCOMMANDBUF_XR_XT_MM2_0 VSS XCORE_XCOMMANDBUF_XR_EB XCORE_HELD_BUFFER VDD P W=4.5u L=0.8u
MXCORE_XTOP_XI_MN_0 XCORE_XTOP_EB XCORE_E1 VSS VSS N W=2.5u L=0.8u
MXCORE_XTOP_XI_MP_0 XCORE_XTOP_EB XCORE_E1 VDD VDD P W=4.5u L=0.8u
MXCORE_XTOP_XT_MM1_0 XCORE_RT XCORE_E1 XCORE_HELD_BUFFER VSS N W=2.5u L=0.8u
MXCORE_XTOP_XT_MM2_0 XCORE_RT XCORE_XTOP_EB XCORE_HELD_BUFFER VDD P W=4.5u L=0.8u
MXCORE_XBOTTOM_XI_MN_0 XCORE_XBOTTOM_EB XCORE_PRE VSS VSS N W=2.5u L=0.8u
MXCORE_XBOTTOM_XI_MP_0 XCORE_XBOTTOM_EB XCORE_PRE VDD VDD P W=4.5u L=0.8u
MXCORE_XBOTTOM_XT_MM1_0 VSS XCORE_PRE XCORE_RB VSS N W=2.5u L=0.8u
MXCORE_XBOTTOM_XT_MM2_0 VSS XCORE_XBOTTOM_EB XCORE_RB VDD P W=4.5u L=0.8u
MXCORE_XBYPASS_XI_MN_0 XCORE_XBYPASS_EB XCORE_E2 VSS VSS N W=2.5u L=0.8u
MXCORE_XBYPASS_XI_MP_0 XCORE_XBYPASS_EB XCORE_E2 VDD VDD P W=4.5u L=0.8u
MXCORE_XBYPASS_XT_MM1_0 XCORE_MIX XCORE_E2 XCORE_HELD_BUFFER VSS N W=2.5u L=0.8u
MXCORE_XBYPASS_XT_MM2_0 XCORE_MIX XCORE_XBYPASS_EB XCORE_HELD_BUFFER VDD P W=4.5u L=0.8u
MXCORE_XMIXRESET_XI_MN_0 XCORE_XMIXRESET_EB XCORE_E1B VSS VSS N W=2.5u L=0.8u
MXCORE_XMIXRESET_XI_MP_0 XCORE_XMIXRESET_EB XCORE_E1B VDD VDD P W=4.5u L=0.8u
MXCORE_XMIXRESET_XT_MM1_0 VSS XCORE_E1B XCORE_MIX VSS N W=2.5u L=0.8u
MXCORE_XMIXRESET_XT_MM2_0 VSS XCORE_XMIXRESET_EB XCORE_MIX VDD P W=4.5u L=0.8u
MXCORE_XOUTRESET_XI_MN_0 XCORE_XOUTRESET_EB XCORE_E1B VSS VSS N W=2.5u L=0.8u
MXCORE_XOUTRESET_XI_MP_0 XCORE_XOUTRESET_EB XCORE_E1B VDD VDD P W=4.5u L=0.8u
MXCORE_XOUTRESET_XT_MM1_0 VSS XCORE_E1B XCORE_CM_X VSS N W=2.5u L=0.8u
MXCORE_XOUTRESET_XT_MM2_0 VSS XCORE_XOUTRESET_EB XCORE_CM_X VDD P W=4.5u L=0.8u
MXTIMING_XN_MP1_0 XTIMING_XN_SERIES_NODE XTIMING_DELAY1 VDD VDD P W=9.0u L=0.8u
MXTIMING_XN_MP2_0 XTIMING_EN_B XTIMING_DELAY2 XTIMING_XN_SERIES_NODE VDD P W=9.0u L=0.8u
MXCORE_MB_0 XCORE_NB XCORE_NB VSS VSS N W=10.0u L=3.2u
MXCORE_MNB_0 XCORE_PB XCORE_NB VSS VSS N W=10.0u L=3.2u
MXCORE_XRN_MP1_0 XCORE_XRN_SERIES_NODE PHI1 VDD VDD P W=9.0u L=0.8u
MXCORE_XRN_MP2_0 XCORE_RESET_BAR XCORE_RESET_ACTIVE XCORE_XRN_SERIES_NODE VDD P W=9.0u L=0.8u
MXCORE_XL1_XQ_MP1_0 XCORE_XL1_XQ_SERIES_NODE XCORE_RESET_ALL VDD VDD P W=9.0u L=0.8u
MXCORE_XL1_XQ_MP2_0 XCORE_E1 XCORE_E1B XCORE_XL1_XQ_SERIES_NODE VDD P W=9.0u L=0.8u
MXCORE_XL1_XQB_MP1_0 XCORE_XL1_XQB_SERIES_NODE PHIT VDD VDD P W=9.0u L=0.8u
MXCORE_XL1_XQB_MP2_0 XCORE_E1B XCORE_E1 XCORE_XL1_XQB_SERIES_NODE VDD P W=9.0u L=0.8u
MXCORE_XL2_XQ_MP1_0 XCORE_XL2_XQ_SERIES_NODE XCORE_RESET_ALL VDD VDD P W=9.0u L=0.8u
MXCORE_XL2_XQ_MP2_0 XCORE_E2 XCORE_E2B XCORE_XL2_XQ_SERIES_NODE VDD P W=9.0u L=0.8u
MXCORE_XL2_XQB_MP1_0 XCORE_XL2_XQB_SERIES_NODE PHI2 VDD VDD P W=9.0u L=0.8u
MXCORE_XL2_XQB_MP2_0 XCORE_E2B XCORE_E2 XCORE_XL2_XQB_SERIES_NODE VDD P W=9.0u L=0.8u
MXCORE_XCOMMANDBUF_MT_0 XCORE_XCOMMANDBUF_BT XCORE_PB VDD VDD P W=10.0u L=3.2u
MXCORE_XCOMMANDBUF_ML_0 XCORE_XCOMMANDBUF_BL XCORE_HELD_BUFFER XCORE_XCOMMANDBUF_BT VDD P W=8.0u L=2.4u
MXCORE_XCOMMANDBUF_MR_0 XCORE_XCOMMANDBUF_GAIN XCORE_CM_HOLD XCORE_XCOMMANDBUF_BT VDD P W=8.0u L=2.4u
MXCORE_XCOMMANDBUF_MNL_0 XCORE_XCOMMANDBUF_BL XCORE_XCOMMANDBUF_BL VSS VSS N W=10.0u L=3.2u
MXCORE_XCOMMANDBUF_MNR_0 XCORE_XCOMMANDBUF_GAIN XCORE_XCOMMANDBUF_BL VSS VSS N W=10.0u L=3.2u
MXCORE_MBTAIL_0 XCORE_BT XCORE_PB VDD VDD P W=10.0u L=3.2u
MXCORE_MBL_0 XCORE_BL XCORE_CM_X XCORE_BT VDD P W=8.0u L=2.4u
MXCORE_MBR_0 XCORE_GAIN XCORE_MIX XCORE_BT VDD P W=8.0u L=2.4u
MXCORE_MBNL_0 XCORE_BL XCORE_BL VSS VSS N W=10.0u L=3.2u
MXCORE_MBNR_0 XCORE_GAIN XCORE_BL VSS VSS N W=10.0u L=3.2u
MXCORE_MPB_0 XCORE_PB XCORE_PB VDD VDD P W=20.0u L=3.2u
MXCORE_XCOMMANDBUF_MOUT_0 XCORE_HELD_BUFFER XCORE_XCOMMANDBUF_GAIN VSS VSS N W=20.0u L=2.4u
MXCORE_MOUT_0 XCORE_CM_X XCORE_GAIN VSS VSS N W=20.0u L=2.4u
MXCORE_MCORRP_0 SUMP XCORE_CM_X SUMP SUMP P W=20.0u L=10.0u
MXCORE_MCORRP_1 SUMP XCORE_CM_X SUMP SUMP P W=20.0u L=10.0u
MXCORE_MCORRP_2 SUMP XCORE_CM_X SUMP SUMP P W=20.0u L=10.0u
MXCORE_MCORRP_3 SUMP XCORE_CM_X SUMP SUMP P W=20.0u L=10.0u
MXCORE_MCORRP_4 SUMP XCORE_CM_X SUMP SUMP P W=20.0u L=10.0u
MXCORE_MCORRP_5 SUMP XCORE_CM_X SUMP SUMP P W=20.0u L=10.0u
MXCORE_MCORRP_6 SUMP XCORE_CM_X SUMP SUMP P W=20.0u L=10.0u
MXCORE_MCORRP_7 SUMP XCORE_CM_X SUMP SUMP P W=20.0u L=10.0u
MXCORE_MCORRP_8 SUMP XCORE_CM_X SUMP SUMP P W=20.0u L=10.0u
MXCORE_MCORRP_9 SUMP XCORE_CM_X SUMP SUMP P W=20.0u L=10.0u
MXCORE_MCORRP_10 SUMP XCORE_CM_X SUMP SUMP P W=20.0u L=10.0u
MXCORE_MCORRP_11 SUMP XCORE_CM_X SUMP SUMP P W=20.0u L=10.0u
MXCORE_MCORRP_12 SUMP XCORE_CM_X SUMP SUMP P W=20.0u L=10.0u
MXCORE_MCORRP_13 SUMP XCORE_CM_X SUMP SUMP P W=20.0u L=10.0u
MXCORE_MCORRP_14 SUMP XCORE_CM_X SUMP SUMP P W=20.0u L=10.0u
MXCORE_MCORRP_15 SUMP XCORE_CM_X SUMP SUMP P W=20.0u L=10.0u
MXCORE_MCORRP_16 SUMP XCORE_CM_X SUMP SUMP P W=20.0u L=10.0u
MXCORE_MCORRP_17 SUMP XCORE_CM_X SUMP SUMP P W=20.0u L=10.0u
MXCORE_MCORRP_18 SUMP XCORE_CM_X SUMP SUMP P W=20.0u L=10.0u
MXCORE_MCORRP_19 SUMP XCORE_CM_X SUMP SUMP P W=20.0u L=10.0u
MXCORE_MCORRP_20 SUMP XCORE_CM_X SUMP SUMP P W=20.0u L=10.0u
MXCORE_MCORRP_21 SUMP XCORE_CM_X SUMP SUMP P W=20.0u L=10.0u
MXCORE_MCORRP_22 SUMP XCORE_CM_X SUMP SUMP P W=20.0u L=10.0u
MXCORE_MCORRP_23 SUMP XCORE_CM_X SUMP SUMP P W=20.0u L=10.0u
MXCORE_MCORRP_24 SUMP XCORE_CM_X SUMP SUMP P W=20.0u L=10.0u
MXCORE_MCORRP_25 SUMP XCORE_CM_X SUMP SUMP P W=20.0u L=10.0u
MXCORE_MCORRP_26 SUMP XCORE_CM_X SUMP SUMP P W=20.0u L=10.0u
MXCORE_MCORRP_27 SUMP XCORE_CM_X SUMP SUMP P W=20.0u L=10.0u
MXCORE_MCORRP_28 SUMP XCORE_CM_X SUMP SUMP P W=20.0u L=10.0u
MXCORE_MCORRP_29 SUMP XCORE_CM_X SUMP SUMP P W=20.0u L=10.0u
MXCORE_MCORRP_30 SUMP XCORE_CM_X SUMP SUMP P W=20.0u L=10.0u
MXCORE_MCORRP_31 SUMP XCORE_CM_X SUMP SUMP P W=20.0u L=10.0u
MXCORE_MCORRP_32 SUMP XCORE_CM_X SUMP SUMP P W=20.0u L=10.0u
MXCORE_MCORRP_33 SUMP XCORE_CM_X SUMP SUMP P W=20.0u L=10.0u
MXCORE_MCORRP_34 SUMP XCORE_CM_X SUMP SUMP P W=20.0u L=10.0u
MXCORE_MCORRP_35 SUMP XCORE_CM_X SUMP SUMP P W=20.0u L=10.0u
MXCORE_MCORRP_36 SUMP XCORE_CM_X SUMP SUMP P W=20.0u L=10.0u
MXCORE_MCORRP_37 SUMP XCORE_CM_X SUMP SUMP P W=20.0u L=10.0u
MXCORE_MCORRP_38 SUMP XCORE_CM_X SUMP SUMP P W=20.0u L=10.0u
MXCORE_MCORRP_39 SUMP XCORE_CM_X SUMP SUMP P W=20.0u L=10.0u
MXCORE_MCORRN_0 SUMN XCORE_CM_X SUMN SUMN P W=20.0u L=10.0u
MXCORE_MCORRN_1 SUMN XCORE_CM_X SUMN SUMN P W=20.0u L=10.0u
MXCORE_MCORRN_2 SUMN XCORE_CM_X SUMN SUMN P W=20.0u L=10.0u
MXCORE_MCORRN_3 SUMN XCORE_CM_X SUMN SUMN P W=20.0u L=10.0u
MXCORE_MCORRN_4 SUMN XCORE_CM_X SUMN SUMN P W=20.0u L=10.0u
MXCORE_MCORRN_5 SUMN XCORE_CM_X SUMN SUMN P W=20.0u L=10.0u
MXCORE_MCORRN_6 SUMN XCORE_CM_X SUMN SUMN P W=20.0u L=10.0u
MXCORE_MCORRN_7 SUMN XCORE_CM_X SUMN SUMN P W=20.0u L=10.0u
MXCORE_MCORRN_8 SUMN XCORE_CM_X SUMN SUMN P W=20.0u L=10.0u
MXCORE_MCORRN_9 SUMN XCORE_CM_X SUMN SUMN P W=20.0u L=10.0u
MXCORE_MCORRN_10 SUMN XCORE_CM_X SUMN SUMN P W=20.0u L=10.0u
MXCORE_MCORRN_11 SUMN XCORE_CM_X SUMN SUMN P W=20.0u L=10.0u
MXCORE_MCORRN_12 SUMN XCORE_CM_X SUMN SUMN P W=20.0u L=10.0u
MXCORE_MCORRN_13 SUMN XCORE_CM_X SUMN SUMN P W=20.0u L=10.0u
MXCORE_MCORRN_14 SUMN XCORE_CM_X SUMN SUMN P W=20.0u L=10.0u
MXCORE_MCORRN_15 SUMN XCORE_CM_X SUMN SUMN P W=20.0u L=10.0u
MXCORE_MCORRN_16 SUMN XCORE_CM_X SUMN SUMN P W=20.0u L=10.0u
MXCORE_MCORRN_17 SUMN XCORE_CM_X SUMN SUMN P W=20.0u L=10.0u
MXCORE_MCORRN_18 SUMN XCORE_CM_X SUMN SUMN P W=20.0u L=10.0u
MXCORE_MCORRN_19 SUMN XCORE_CM_X SUMN SUMN P W=20.0u L=10.0u
MXCORE_MCORRN_20 SUMN XCORE_CM_X SUMN SUMN P W=20.0u L=10.0u
MXCORE_MCORRN_21 SUMN XCORE_CM_X SUMN SUMN P W=20.0u L=10.0u
MXCORE_MCORRN_22 SUMN XCORE_CM_X SUMN SUMN P W=20.0u L=10.0u
MXCORE_MCORRN_23 SUMN XCORE_CM_X SUMN SUMN P W=20.0u L=10.0u
MXCORE_MCORRN_24 SUMN XCORE_CM_X SUMN SUMN P W=20.0u L=10.0u
MXCORE_MCORRN_25 SUMN XCORE_CM_X SUMN SUMN P W=20.0u L=10.0u
MXCORE_MCORRN_26 SUMN XCORE_CM_X SUMN SUMN P W=20.0u L=10.0u
MXCORE_MCORRN_27 SUMN XCORE_CM_X SUMN SUMN P W=20.0u L=10.0u
MXCORE_MCORRN_28 SUMN XCORE_CM_X SUMN SUMN P W=20.0u L=10.0u
MXCORE_MCORRN_29 SUMN XCORE_CM_X SUMN SUMN P W=20.0u L=10.0u
MXCORE_MCORRN_30 SUMN XCORE_CM_X SUMN SUMN P W=20.0u L=10.0u
MXCORE_MCORRN_31 SUMN XCORE_CM_X SUMN SUMN P W=20.0u L=10.0u
MXCORE_MCORRN_32 SUMN XCORE_CM_X SUMN SUMN P W=20.0u L=10.0u
MXCORE_MCORRN_33 SUMN XCORE_CM_X SUMN SUMN P W=20.0u L=10.0u
MXCORE_MCORRN_34 SUMN XCORE_CM_X SUMN SUMN P W=20.0u L=10.0u
MXCORE_MCORRN_35 SUMN XCORE_CM_X SUMN SUMN P W=20.0u L=10.0u
MXCORE_MCORRN_36 SUMN XCORE_CM_X SUMN SUMN P W=20.0u L=10.0u
MXCORE_MCORRN_37 SUMN XCORE_CM_X SUMN SUMN P W=20.0u L=10.0u
MXCORE_MCORRN_38 SUMN XCORE_CM_X SUMN SUMN P W=20.0u L=10.0u
MXCORE_MCORRN_39 SUMN XCORE_CM_X SUMN SUMN P W=20.0u L=10.0u
MXCORE_MCINT_0 VDD XCORE_VINT VDD VDD P W=20.0u L=506.75u
MXCORE_MCINT_1 VDD XCORE_VINT VDD VDD P W=20.0u L=506.75u
MXCORE_MCINT_2 VDD XCORE_VINT VDD VDD P W=20.0u L=506.75u
MXCORE_MCINT_3 VDD XCORE_VINT VDD VDD P W=20.0u L=506.75u
MXCORE_MCINT_4 VDD XCORE_VINT VDD VDD P W=20.0u L=506.75u
MXCORE_MCHOLD_0 VDD XCORE_CM_HOLD VDD VDD P W=20.0u L=101.35000000000001u
MXCORE_MCHOLD_1 VDD XCORE_CM_HOLD VDD VDD P W=20.0u L=101.35000000000001u
MXCORE_MCHOLD_2 VDD XCORE_CM_HOLD VDD VDD P W=20.0u L=101.35000000000001u
MXCORE_MCHOLD_3 VDD XCORE_CM_HOLD VDD VDD P W=20.0u L=101.35000000000001u
MXCORE_MCHOLD_4 VDD XCORE_CM_HOLD VDD VDD P W=20.0u L=101.35000000000001u
MXCORE_XCOMMANDBUF_MCOMP_0 XCORE_HELD_BUFFER XCORE_XCOMMANDBUF_GAIN XCORE_HELD_BUFFER XCORE_HELD_BUFFER P W=20.0u L=101.35000000000001u
MXCORE_XCOMMANDBUF_MCOMP_1 XCORE_HELD_BUFFER XCORE_XCOMMANDBUF_GAIN XCORE_HELD_BUFFER XCORE_HELD_BUFFER P W=20.0u L=101.35000000000001u
MXCORE_XCOMMANDBUF_MCOMP_2 XCORE_HELD_BUFFER XCORE_XCOMMANDBUF_GAIN XCORE_HELD_BUFFER XCORE_HELD_BUFFER P W=20.0u L=101.35000000000001u
MXCORE_XCOMMANDBUF_MCOMP_3 XCORE_HELD_BUFFER XCORE_XCOMMANDBUF_GAIN XCORE_HELD_BUFFER XCORE_HELD_BUFFER P W=20.0u L=101.35000000000001u
MXCORE_XCOMMANDBUF_MCOMP_4 XCORE_HELD_BUFFER XCORE_XCOMMANDBUF_GAIN XCORE_HELD_BUFFER XCORE_HELD_BUFFER P W=20.0u L=101.35000000000001u
MXCORE_MCOMP_0 XCORE_CM_X XCORE_GAIN XCORE_CM_X XCORE_CM_X P W=20.0u L=101.35000000000001u
MXCORE_MCOMP_1 XCORE_CM_X XCORE_GAIN XCORE_CM_X XCORE_CM_X P W=20.0u L=101.35000000000001u
MXCORE_MCOMP_2 XCORE_CM_X XCORE_GAIN XCORE_CM_X XCORE_CM_X P W=20.0u L=101.35000000000001u
MXCORE_MCOMP_3 XCORE_CM_X XCORE_GAIN XCORE_CM_X XCORE_CM_X P W=20.0u L=101.35000000000001u
MXCORE_MCOMP_4 XCORE_CM_X XCORE_GAIN XCORE_CM_X XCORE_CM_X P W=20.0u L=101.35000000000001u
MXCORE_XCOMMANDBUF_MEN_0 XCORE_XCOMMANDBUF_LP XCORE_XCOMMANDBUF_DISABLED VDD VDD P W=30.0u L=0.8u
MXCORE_MLOADEN_0 XCORE_LP XCORE_E1B VDD VDD P W=30.0u L=0.8u
MXCORE_MERRCL_0 XCORE_LEFT XCORE_PCAS XCORE_ERR_LEFT VDD P W=40.0u L=10.0u
MXCORE_MERRCR_0 XCORE_ERROR_OUT XCORE_PCAS XCORE_ERR_RIGHT VDD P W=40.0u L=10.0u
MXCORE_MERRTAIL_0 XCORE_TAIL XCORE_PB VDD VDD P W=50.0u L=3.2u
MXCORE_XCOMMANDBUF_MLOAD_0 XCORE_HELD_BUFFER XCORE_PB XCORE_XCOMMANDBUF_LP VDD P W=100.0u L=3.2u
MXCORE_MLOAD_0 XCORE_CM_X XCORE_PB XCORE_LP VDD P W=100.0u L=3.2u
MXCORE_MNERR_L_0 XCORE_LEFT XCORE_LEFT VSS VSS N W=125.0u L=20.0u
MXCORE_MNERR_R_0 XCORE_ERROR_OUT XCORE_LEFT VSS VSS N W=125.0u L=20.0u
MXCORE_MERR_L_0 XCORE_ERR_LEFT VREF XCORE_TAIL VDD P W=160.0u L=4.8u
MXCORE_MERR_R_0 XCORE_ERR_RIGHT XCORE_SENSE XCORE_TAIL VDD P W=160.0u L=4.8u
.ends capsense_controller_mos

.subckt controller_rpp_0 A B
R0 A n1 4666.66666667 RPP
R1 n1 n2 4666.66666667 RPP
R2 n2 n3 4666.66666667 RPP
R3 n3 n4 4666.66666667 RPP
R4 n4 n5 4666.66666667 RPP
R5 n5 n6 4666.66666667 RPP
R6 n6 n7 4666.66666667 RPP
R7 n7 n8 4666.66666667 RPP
R8 n8 n9 4666.66666667 RPP
R9 n9 n10 4666.66666667 RPP
R10 n10 n11 4666.66666667 RPP
R11 n11 n12 4666.66666667 RPP
R12 n12 n13 4666.66666667 RPP
R13 n13 n14 4666.66666667 RPP
R14 n14 n15 4666.66666667 RPP
R15 n15 n16 4666.66666667 RPP
R16 n16 n17 4666.66666667 RPP
R17 n17 n18 4666.66666667 RPP
R18 n18 n19 4666.66666667 RPP
R19 n19 n20 4666.66666667 RPP
R20 n20 n21 4666.66666667 RPP
R21 n21 n22 4666.66666667 RPP
R22 n22 n23 4666.66666667 RPP
R23 n23 n24 4666.66666667 RPP
R24 n24 n25 4666.66666667 RPP
R25 n25 n26 4666.66666667 RPP
R26 n26 n27 4666.66666667 RPP
R27 n27 n28 4666.66666667 RPP
R28 n28 n29 4666.66666667 RPP
R29 n29 n30 4666.66666667 RPP
R30 n30 n31 4666.66666667 RPP
R31 n31 n32 4666.66666667 RPP
R32 n32 n33 4666.66666667 RPP
R33 n33 n34 4666.66666667 RPP
R34 n34 n35 4666.66666667 RPP
R35 n35 n36 4666.66666667 RPP
R36 n36 n37 4666.66666667 RPP
R37 n37 n38 4666.66666667 RPP
R38 n38 n39 4666.66666667 RPP
R39 n39 n40 4666.66666667 RPP
R40 n40 n41 4666.66666667 RPP
R41 n41 n42 4666.66666667 RPP
R42 n42 n43 4666.66666667 RPP
R43 n43 n44 4666.66666667 RPP
R44 n44 n45 4666.66666667 RPP
R45 n45 n46 4666.66666667 RPP
R46 n46 n47 4666.66666667 RPP
R47 n47 n48 4666.66666667 RPP
R48 n48 n49 4666.66666667 RPP
R49 n49 n50 4666.66666667 RPP
R50 n50 n51 4666.66666667 RPP
R51 n51 n52 4666.66666667 RPP
R52 n52 n53 4666.66666667 RPP
R53 n53 n54 4666.66666667 RPP
R54 n54 n55 4666.66666667 RPP
R55 n55 n56 4666.66666667 RPP
R56 n56 n57 4666.66666667 RPP
R57 n57 n58 4666.66666667 RPP
R58 n58 n59 4666.66666667 RPP
R59 n59 n60 4666.66666667 RPP
R60 n60 n61 4666.66666667 RPP
R61 n61 n62 4666.66666667 RPP
R62 n62 n63 4666.66666667 RPP
R63 n63 n64 4666.66666667 RPP
R64 n64 n65 4666.66666667 RPP
R65 n65 n66 4666.66666667 RPP
R66 n66 n67 4666.66666667 RPP
R67 n67 n68 4666.66666667 RPP
R68 n68 n69 4666.66666667 RPP
R69 n69 n70 4666.66666667 RPP
R70 n70 n71 4666.66666667 RPP
R71 n71 n72 4666.66666667 RPP
R72 n72 n73 4666.66666667 RPP
R73 n73 n74 4666.66666667 RPP
R74 n74 n75 4666.66666667 RPP
R75 n75 n76 4666.66666667 RPP
R76 n76 n77 4666.66666667 RPP
R77 n77 n78 4666.66666667 RPP
R78 n78 n79 4666.66666667 RPP
R79 n79 n80 4666.66666667 RPP
R80 n80 n81 4666.66666667 RPP
R81 n81 n82 4666.66666667 RPP
R82 n82 n83 4666.66666667 RPP
R83 n83 n84 4666.66666667 RPP
R84 n84 n85 4666.66666667 RPP
R85 n85 n86 4666.66666667 RPP
R86 n86 n87 4666.66666667 RPP
R87 n87 n88 4666.66666667 RPP
R88 n88 n89 4666.66666667 RPP
R89 n89 n90 4666.66666667 RPP
R90 n90 n91 4666.66666667 RPP
R91 n91 n92 4666.66666667 RPP
R92 n92 n93 4666.66666667 RPP
R93 n93 n94 4666.66666667 RPP
R94 n94 n95 4666.66666667 RPP
R95 n95 n96 4666.66666667 RPP
R96 n96 n97 4666.66666667 RPP
R97 n97 n98 4666.66666667 RPP
R98 n98 n99 4666.66666667 RPP
R99 n99 n100 4666.66666667 RPP
R100 n100 n101 4666.66666667 RPP
R101 n101 n102 4666.66666667 RPP
R102 n102 n103 4666.66666667 RPP
R103 n103 n104 4666.66666667 RPP
R104 n104 n105 4666.66666667 RPP
R105 n105 n106 4666.66666667 RPP
R106 n106 n107 4666.66666667 RPP
R107 n107 n108 4666.66666667 RPP
R108 n108 n109 4666.66666667 RPP
R109 n109 n110 4666.66666667 RPP
R110 n110 n111 4666.66666667 RPP
R111 n111 n112 4666.66666667 RPP
R112 n112 n113 4666.66666667 RPP
R113 n113 n114 4666.66666667 RPP
R114 n114 n115 4666.66666667 RPP
R115 n115 n116 4666.66666667 RPP
R116 n116 n117 4666.66666667 RPP
R117 n117 n118 4666.66666667 RPP
R118 n118 n119 4666.66666667 RPP
R119 n119 n120 4666.66666667 RPP
R120 n120 n121 4666.66666667 RPP
R121 n121 n122 4666.66666667 RPP
R122 n122 n123 4666.66666667 RPP
R123 n123 n124 4666.66666667 RPP
R124 n124 n125 4666.66666667 RPP
R125 n125 n126 4666.66666667 RPP
R126 n126 n127 4666.66666667 RPP
R127 n127 n128 4666.66666667 RPP
R128 n128 n129 4666.66666667 RPP
R129 n129 n130 4666.66666667 RPP
R130 n130 n131 4666.66666667 RPP
R131 n131 n132 4666.66666667 RPP
R132 n132 n133 4666.66666667 RPP
R133 n133 n134 4666.66666667 RPP
R134 n134 n135 4666.66666667 RPP
R135 n135 n136 4666.66666667 RPP
R136 n136 n137 4666.66666667 RPP
R137 n137 n138 4666.66666667 RPP
R138 n138 n139 4666.66666667 RPP
R139 n139 n140 4666.66666667 RPP
R140 n140 n141 4666.66666667 RPP
R141 n141 n142 4666.66666667 RPP
R142 n142 n143 4666.66666667 RPP
R143 n143 n144 4666.66666667 RPP
R144 n144 n145 4666.66666667 RPP
R145 n145 n146 4666.66666667 RPP
R146 n146 n147 4666.66666667 RPP
R147 n147 n148 4666.66666667 RPP
R148 n148 n149 4666.66666667 RPP
R149 n149 n150 4666.66666667 RPP
R150 n150 n151 4666.66666667 RPP
R151 n151 n152 4666.66666667 RPP
R152 n152 n153 4666.66666667 RPP
R153 n153 n154 4666.66666667 RPP
R154 n154 n155 4666.66666667 RPP
R155 n155 n156 4666.66666667 RPP
R156 n156 n157 4666.66666667 RPP
R157 n157 n158 4666.66666667 RPP
R158 n158 n159 4666.66666667 RPP
R159 n159 n160 4666.66666667 RPP
R160 n160 n161 4666.66666667 RPP
R161 n161 n162 4666.66666667 RPP
R162 n162 n163 4666.66666667 RPP
R163 n163 n164 4666.66666667 RPP
R164 n164 n165 4666.66666667 RPP
R165 n165 n166 4666.66666667 RPP
R166 n166 n167 4666.66666667 RPP
R167 n167 n168 4666.66666667 RPP
R168 n168 n169 4666.66666667 RPP
R169 n169 n170 4666.66666667 RPP
R170 n170 n171 4666.66666667 RPP
R171 n171 n172 4666.66666667 RPP
R172 n172 n173 4666.66666667 RPP
R173 n173 n174 4666.66666667 RPP
R174 n174 n175 4666.66666667 RPP
R175 n175 n176 4666.66666667 RPP
R176 n176 n177 4666.66666667 RPP
R177 n177 n178 4666.66666667 RPP
R178 n178 n179 4666.66666667 RPP
R179 n179 n180 4666.66666667 RPP
R180 n180 n181 4666.66666667 RPP
R181 n181 n182 4666.66666667 RPP
R182 n182 n183 4666.66666667 RPP
R183 n183 n184 4666.66666667 RPP
R184 n184 n185 4666.66666667 RPP
R185 n185 n186 4666.66666667 RPP
R186 n186 n187 4666.66666667 RPP
R187 n187 n188 4666.66666667 RPP
R188 n188 n189 4666.66666667 RPP
R189 n189 n190 4666.66666667 RPP
R190 n190 n191 4666.66666667 RPP
R191 n191 n192 4666.66666667 RPP
R192 n192 n193 4666.66666667 RPP
R193 n193 n194 4666.66666667 RPP
R194 n194 n195 4666.66666667 RPP
R195 n195 n196 4666.66666667 RPP
R196 n196 n197 4666.66666667 RPP
R197 n197 n198 4666.66666667 RPP
R198 n198 n199 4666.66666667 RPP
R199 n199 n200 4666.66666667 RPP
R200 n200 n201 4666.66666667 RPP
R201 n201 n202 4666.66666667 RPP
R202 n202 n203 4666.66666667 RPP
R203 n203 n204 4666.66666667 RPP
R204 n204 n205 4666.66666667 RPP
R205 n205 n206 4666.66666667 RPP
R206 n206 n207 4666.66666667 RPP
R207 n207 n208 4666.66666667 RPP
R208 n208 n209 4666.66666667 RPP
R209 n209 n210 4666.66666667 RPP
R210 n210 n211 4666.66666667 RPP
R211 n211 n212 4666.66666667 RPP
R212 n212 n213 4666.66666667 RPP
R213 n213 n214 4666.66666667 RPP
R214 n214 B 1333.325 RPP
.ends controller_rpp_0

.subckt controller_rpp_1 A B
R0 A n1 4666.66666667 RPP
R1 n1 n2 4666.66666667 RPP
R2 n2 n3 4666.66666667 RPP
R3 n3 n4 4666.66666667 RPP
R4 n4 n5 4666.66666667 RPP
R5 n5 n6 4666.66666667 RPP
R6 n6 n7 4666.66666667 RPP
R7 n7 n8 4666.66666667 RPP
R8 n8 n9 4666.66666667 RPP
R9 n9 n10 4666.66666667 RPP
R10 n10 n11 4666.66666667 RPP
R11 n11 n12 4666.66666667 RPP
R12 n12 n13 4666.66666667 RPP
R13 n13 n14 4666.66666667 RPP
R14 n14 n15 4666.66666667 RPP
R15 n15 n16 4666.66666667 RPP
R16 n16 n17 4666.66666667 RPP
R17 n17 n18 4666.66666667 RPP
R18 n18 n19 4666.66666667 RPP
R19 n19 n20 4666.66666667 RPP
R20 n20 n21 4666.66666667 RPP
R21 n21 B 2000.01666667 RPP
.ends controller_rpp_1

.subckt controller_rpp_2 A B
R0 A n1 4666.66666667 RPP
R1 n1 n2 4666.66666667 RPP
R2 n2 n3 4666.66666667 RPP
R3 n3 n4 4666.66666667 RPP
R4 n4 n5 4666.66666667 RPP
R5 n5 n6 4666.66666667 RPP
R6 n6 n7 4666.66666667 RPP
R7 n7 n8 4666.66666667 RPP
R8 n8 n9 4666.66666667 RPP
R9 n9 n10 4666.66666667 RPP
R10 n10 n11 4666.66666667 RPP
R11 n11 n12 4666.66666667 RPP
R12 n12 n13 4666.66666667 RPP
R13 n13 n14 4666.66666667 RPP
R14 n14 n15 4666.66666667 RPP
R15 n15 n16 4666.66666667 RPP
R16 n16 n17 4666.66666667 RPP
R17 n17 n18 4666.66666667 RPP
R18 n18 n19 4666.66666667 RPP
R19 n19 n20 4666.66666667 RPP
R20 n20 n21 4666.66666667 RPP
R21 n21 n22 4666.66666667 RPP
R22 n22 n23 4666.66666667 RPP
R23 n23 n24 4666.66666667 RPP
R24 n24 n25 4666.66666667 RPP
R25 n25 n26 4666.66666667 RPP
R26 n26 n27 4666.66666667 RPP
R27 n27 n28 4666.66666667 RPP
R28 n28 n29 4666.66666667 RPP
R29 n29 n30 4666.66666667 RPP
R30 n30 n31 4666.66666667 RPP
R31 n31 n32 4666.66666667 RPP
R32 n32 n33 4666.66666667 RPP
R33 n33 n34 4666.66666667 RPP
R34 n34 n35 4666.66666667 RPP
R35 n35 n36 4666.66666667 RPP
R36 n36 n37 4666.66666667 RPP
R37 n37 n38 4666.66666667 RPP
R38 n38 n39 4666.66666667 RPP
R39 n39 n40 4666.66666667 RPP
R40 n40 n41 4666.66666667 RPP
R41 n41 n42 4666.66666667 RPP
R42 n42 B 3999.975 RPP
.ends controller_rpp_2

.subckt controller_rpp_3 A B
R0 A n1 4666.66666667 RPP
R1 n1 n2 4666.66666667 RPP
R2 n2 n3 4666.66666667 RPP
R3 n3 n4 4666.66666667 RPP
R4 n4 n5 4666.66666667 RPP
R5 n5 n6 4666.66666667 RPP
R6 n6 n7 4666.66666667 RPP
R7 n7 n8 4666.66666667 RPP
R8 n8 n9 4666.66666667 RPP
R9 n9 n10 4666.66666667 RPP
R10 n10 n11 4666.66666667 RPP
R11 n11 n12 4666.66666667 RPP
R12 n12 n13 4666.66666667 RPP
R13 n13 B 3333.34166667 RPP
.ends controller_rpp_3

.subckt controller_rpp_4 A B
R0 A n1 4666.66666667 RPP
R1 n1 n2 4666.66666667 RPP
R2 n2 n3 4666.66666667 RPP
R3 n3 n4 4666.66666667 RPP
R4 n4 n5 4666.66666667 RPP
R5 n5 n6 4666.66666667 RPP
R6 n6 n7 4666.66666667 RPP
R7 n7 n8 4666.66666667 RPP
R8 n8 n9 4666.66666667 RPP
R9 n9 n10 4666.66666667 RPP
R10 n10 n11 4666.66666667 RPP
R11 n11 n12 4666.66666667 RPP
R12 n12 n13 4666.66666667 RPP
R13 n13 n14 4666.66666667 RPP
R14 n14 n15 4666.66666667 RPP
R15 n15 n16 4666.66666667 RPP
R16 n16 n17 4666.66666667 RPP
R17 n17 n18 4666.66666667 RPP
R18 n18 n19 4666.66666667 RPP
R19 n19 n20 4666.66666667 RPP
R20 n20 n21 4666.66666667 RPP
R21 n21 n22 4666.66666667 RPP
R22 n22 n23 4666.66666667 RPP
R23 n23 n24 4666.66666667 RPP
R24 n24 n25 4666.66666667 RPP
R25 n25 n26 4666.66666667 RPP
R26 n26 n27 4666.66666667 RPP
R27 n27 n28 4666.66666667 RPP
R28 n28 n29 4666.66666667 RPP
R29 n29 B 666.691666667 RPP
.ends controller_rpp_4

.subckt capsense_complete_controller SUMP SUMN VDD VSS VREF PHI1 PHIT PHI2 CLK_1MHZ SAMPLE_VALID RST_N
XMOS SUMP SUMN VDD VSS VREF PHI1 PHIT PHI2 CLK_1MHZ SAMPLE_VALID RST_N XTIMING_XFF1_11 XTIMING_XFF1_12 XTIMING_XFF1_3 XTIMING_XFF1_4 XTIMING_XFF1_6 XTIMING_XFF1_7 XTIMING_XFF1_8 XTIMING_XFF1_13 XTIMING_UNUSED_QB1 XTIMING_DELAY1 XTIMING_XFF1_29 XTIMING_XFF1_30 XTIMING_XFF2_11 XTIMING_XFF2_12 XTIMING_XFF2_3 XTIMING_XFF2_4 XTIMING_XFF2_6 XTIMING_XFF2_7 XTIMING_XFF2_8 XTIMING_XFF2_13 XTIMING_UNUSED_QB2 XTIMING_DELAY2 XTIMING_XFF2_29 XTIMING_XFF2_30 XTIMING_EN_B SAMPLE_EN XCORE_SENSE XCORE_SAMPLE_B XCORE_XSAMPLE_EB XCORE_VINT XCORE_ERROR_OUT XCORE_XDUMP_EB XCORE_XHOLD_EB XCORE_CM_HOLD XCORE_RESET_ACTIVE XCORE_XINIT_EB XCORE_XINITH_EB XCORE_RESET_BAR XCORE_RESET_ALL XCORE_E1 XCORE_E1B XCORE_E2 XCORE_E2B XCORE_PRE_B XCORE_XPREN_SERIES_NODE XCORE_PRE XCORE_XCOMMANDBUF_DISABLED XCORE_XCOMMANDBUF_XR_EB XCORE_HELD_BUFFER XCORE_XTOP_EB XCORE_RT XCORE_XBOTTOM_EB XCORE_RB XCORE_XBYPASS_EB XCORE_MIX XCORE_XMIXRESET_EB XCORE_XOUTRESET_EB XCORE_CM_X XTIMING_XN_SERIES_NODE XCORE_NB XCORE_PB XCORE_XRN_SERIES_NODE XCORE_XL1_XQ_SERIES_NODE XCORE_XL1_XQB_SERIES_NODE XCORE_XL2_XQ_SERIES_NODE XCORE_XL2_XQB_SERIES_NODE XCORE_XCOMMANDBUF_BT XCORE_XCOMMANDBUF_BL XCORE_XCOMMANDBUF_GAIN XCORE_BT XCORE_BL XCORE_GAIN XCORE_XCOMMANDBUF_LP XCORE_LP XCORE_LEFT XCORE_PCAS XCORE_ERR_LEFT XCORE_ERR_RIGHT XCORE_TAIL capsense_controller_mos
XR0 VDD XCORE_NB controller_rpp_0
XR1 VREF XCORE_PCAS controller_rpp_1
XR2 XCORE_PCAS VSS controller_rpp_2
XR3 XCORE_RT XCORE_MIX controller_rpp_3
XR4 XCORE_MIX XCORE_RB controller_rpp_4
.ends capsense_complete_controller

.subckt Input_VCM_bias_stabilizer SUMP SUMN VDD VSS VREF PHI1 PHIT PHI2 CLK_1MHZ SAMPLE_VALID RST_N
XCORE SUMP SUMN VDD VSS VREF PHI1 PHIT PHI2 CLK_1MHZ SAMPLE_VALID RST_N capsense_complete_controller
.ends Input_VCM_bias_stabilizer

.subckt capsense_bias_mos REF VDD VSS VBN VBP IREF NB BN_FB SENSE
MMB NB NB VSS VSS N W=20.0u L=2.4u
MXBN_MT XBN_TAIL NB VSS VSS N W=7.5u L=2.4u
MXBN_M1 XBN_LEFT BN_FB XBN_TAIL VSS N W=15.0u L=2.4u
MXBN_M2 XBN_GAIN REF XBN_TAIL VSS N W=15.0u L=2.4u
MXBN_MP1 XBN_LEFT XBN_LEFT VDD VDD P W=7.5u L=2.4u
MXBN_MP2 XBN_GAIN XBN_LEFT VDD VDD P W=7.5u L=2.4u
MXBN_MP3 VBN XBN_GAIN VDD VDD P W=10.0u L=2.4u
MXBN_MN3 VBN NB VSS VSS N W=15.0u L=2.4u
MXBN_MCOMP VBN XBN_GAIN VBN VBN P W=25.0u L=20.0u
MXSET_MT XSET_TAIL NB VSS VSS N W=7.5u L=2.4u
MXSET_M1 XSET_LEFT SENSE XSET_TAIL VSS N W=15.0u L=2.4u
MXSET_M2 XSET_GAIN REF XSET_TAIL VSS N W=15.0u L=2.4u
MXSET_MP1 XSET_LEFT XSET_LEFT VDD VDD P W=7.5u L=2.4u
MXSET_MP2 XSET_GAIN XSET_LEFT VDD VDD P W=7.5u L=2.4u
MXSET_MP3 GATE XSET_GAIN VDD VDD P W=10.0u L=2.4u
MXSET_MN3 GATE NB VSS VSS N W=15.0u L=2.4u
MXSET_MCOMP GATE XSET_GAIN GATE GATE P W=25.0u L=20.0u
MMSET PR GATE SENSE VSS N W=24.0u L=4.0u
MMPD PR PR VDD VDD P W=18.0u L=12.0u
MMPI IREF PR VDD VDD P W=14.0u L=12.0u
MMPN NBP PR VDD VDD P W=18.0u L=12.0u
MMND NBP NBP VSS VSS N W=15.0u L=14.0u
MMNO VBP NBP VSS VSS N W=15.0u L=14.0u
.ends capsense_bias_mos

.subckt bias_XRBIAS A B
R0 A n1 3645.83333333 RPP
R1 n1 n2 3645.83333333 RPP
R2 n2 n3 3645.83333333 RPP
R3 n3 n4 3645.83333333 RPP
R4 n4 n5 3645.83333333 RPP
R5 n5 n6 3645.83333333 RPP
R6 n6 n7 3645.83333333 RPP
R7 n7 n8 3645.83333333 RPP
R8 n8 n9 3645.83333333 RPP
R9 n9 n10 3645.83333333 RPP
R10 n10 n11 3645.83333333 RPP
R11 n11 n12 3645.83333333 RPP
R12 n12 n13 3645.83333333 RPP
R13 n13 n14 3645.83333333 RPP
R14 n14 n15 3645.83333333 RPP
R15 n15 n16 3645.83333333 RPP
R16 n16 n17 3645.83333333 RPP
R17 n17 n18 3645.83333333 RPP
R18 n18 n19 3645.83333333 RPP
R19 n19 n20 3645.83333333 RPP
R20 n20 n21 3645.83333333 RPP
R21 n21 n22 3645.83333333 RPP
R22 n22 n23 3645.83333333 RPP
R23 n23 n24 3645.83333333 RPP
R24 n24 n25 3645.83333333 RPP
R25 n25 n26 3645.83333333 RPP
R26 n26 n27 3645.83333333 RPP
R27 n27 n28 3645.83333333 RPP
R28 n28 n29 3645.83333333 RPP
R29 n29 n30 3645.83333333 RPP
R30 n30 n31 3645.83333333 RPP
R31 n31 n32 3645.83333333 RPP
R32 n32 n33 3645.83333333 RPP
R33 n33 n34 3645.83333333 RPP
R34 n34 n35 3645.83333333 RPP
R35 n35 n36 3645.83333333 RPP
R36 n36 n37 3645.83333333 RPP
R37 n37 n38 3645.83333333 RPP
R38 n38 n39 3645.83333333 RPP
R39 n39 n40 3645.83333333 RPP
R40 n40 n41 3645.83333333 RPP
R41 n41 n42 3645.83333333 RPP
R42 n42 n43 3645.83333333 RPP
R43 n43 n44 3645.83333333 RPP
R44 n44 n45 3645.83333333 RPP
R45 n45 n46 3645.83333333 RPP
R46 n46 n47 3645.83333333 RPP
R47 n47 n48 3645.83333333 RPP
R48 n48 n49 3645.83333333 RPP
R49 n49 n50 3645.83333333 RPP
R50 n50 n51 3645.83333333 RPP
R51 n51 n52 3645.83333333 RPP
R52 n52 n53 3645.83333333 RPP
R53 n53 n54 3645.83333333 RPP
R54 n54 n55 3645.83333333 RPP
R55 n55 n56 3645.83333333 RPP
R56 n56 n57 3645.83333333 RPP
R57 n57 n58 3645.83333333 RPP
R58 n58 n59 3645.83333333 RPP
R59 n59 n60 3645.83333333 RPP
R60 n60 n61 3645.83333333 RPP
R61 n61 n62 3645.83333333 RPP
R62 n62 n63 3645.83333333 RPP
R63 n63 n64 3645.83333333 RPP
R64 n64 n65 3645.83333333 RPP
R65 n65 n66 3645.83333333 RPP
R66 n66 n67 3645.83333333 RPP
R67 n67 n68 3645.83333333 RPP
R68 n68 n69 3645.83333333 RPP
R69 n69 n70 3645.83333333 RPP
R70 n70 n71 3645.83333333 RPP
R71 n71 n72 3645.83333333 RPP
R72 n72 n73 3645.83333333 RPP
R73 n73 n74 3645.83333333 RPP
R74 n74 n75 3645.83333333 RPP
R75 n75 n76 3645.83333333 RPP
R76 n76 n77 3645.83333333 RPP
R77 n77 n78 3645.83333333 RPP
R78 n78 n79 3645.83333333 RPP
R79 n79 n80 3645.83333333 RPP
R80 n80 n81 3645.83333333 RPP
R81 n81 n82 3645.83333333 RPP
R82 n82 n83 3645.83333333 RPP
R83 n83 n84 3645.83333333 RPP
R84 n84 n85 3645.83333333 RPP
R85 n85 n86 3645.83333333 RPP
R86 n86 n87 3645.83333333 RPP
R87 n87 n88 3645.83333333 RPP
R88 n88 n89 3645.83333333 RPP
R89 n89 n90 3645.83333333 RPP
R90 n90 n91 3645.83333333 RPP
R91 n91 n92 3645.83333333 RPP
R92 n92 n93 3645.83333333 RPP
R93 n93 n94 3645.83333333 RPP
R94 n94 n95 3645.83333333 RPP
R95 n95 n96 3645.83333333 RPP
R96 n96 n97 3645.83333333 RPP
R97 n97 n98 3645.83333333 RPP
R98 n98 n99 3645.83333333 RPP
R99 n99 n100 3645.83333333 RPP
R100 n100 n101 3645.83333333 RPP
R101 n101 n102 3645.83333333 RPP
R102 n102 n103 3645.83333333 RPP
R103 n103 n104 3645.83333333 RPP
R104 n104 n105 3645.83333333 RPP
R105 n105 n106 3645.83333333 RPP
R106 n106 n107 3645.83333333 RPP
R107 n107 n108 3645.83333333 RPP
R108 n108 n109 3645.83333333 RPP
R109 n109 n110 3645.83333333 RPP
R110 n110 n111 3645.83333333 RPP
R111 n111 n112 3645.83333333 RPP
R112 n112 n113 3645.83333333 RPP
R113 n113 n114 3645.83333333 RPP
R114 n114 n115 3645.83333333 RPP
R115 n115 n116 3645.83333333 RPP
R116 n116 n117 3645.83333333 RPP
R117 n117 n118 3645.83333333 RPP
R118 n118 n119 3645.83333333 RPP
R119 n119 n120 3645.83333333 RPP
R120 n120 n121 3645.83333333 RPP
R121 n121 n122 3645.83333333 RPP
R122 n122 n123 3645.83333333 RPP
R123 n123 n124 3645.83333333 RPP
R124 n124 n125 3645.83333333 RPP
R125 n125 n126 3645.83333333 RPP
R126 n126 n127 3645.83333333 RPP
R127 n127 n128 3645.83333333 RPP
R128 n128 n129 3645.83333333 RPP
R129 n129 n130 3645.83333333 RPP
R130 n130 n131 3645.83333333 RPP
R131 n131 n132 3645.83333333 RPP
R132 n132 n133 3645.83333333 RPP
R133 n133 n134 3645.83333333 RPP
R134 n134 n135 3645.83333333 RPP
R135 n135 n136 3645.83333333 RPP
R136 n136 n137 3645.83333333 RPP
R137 n137 n138 3645.83333333 RPP
R138 n138 n139 3645.83333333 RPP
R139 n139 n140 3645.83333333 RPP
R140 n140 n141 3645.83333333 RPP
R141 n141 n142 3645.83333333 RPP
R142 n142 n143 3645.83333333 RPP
R143 n143 n144 3645.83333333 RPP
R144 n144 n145 3645.83333333 RPP
R145 n145 n146 3645.83333333 RPP
R146 n146 n147 3645.83333333 RPP
R147 n147 n148 3645.83333333 RPP
R148 n148 n149 3645.83333333 RPP
R149 n149 n150 3645.83333333 RPP
R150 n150 n151 3645.83333333 RPP
R151 n151 n152 3645.83333333 RPP
R152 n152 n153 3645.83333333 RPP
R153 n153 n154 3645.83333333 RPP
R154 n154 n155 3645.83333333 RPP
R155 n155 n156 3645.83333333 RPP
R156 n156 n157 3645.83333333 RPP
R157 n157 n158 3645.83333333 RPP
R158 n158 n159 3645.83333333 RPP
R159 n159 B 3645.83333333 RPP
.ends bias_XRBIAS

.subckt bias_XRT A B
R0 A n1 3645.83333333 RPP
R1 n1 n2 3645.83333333 RPP
R2 n2 n3 3645.83333333 RPP
R3 n3 n4 3645.83333333 RPP
R4 n4 n5 3645.83333333 RPP
R5 n5 n6 3645.83333333 RPP
R6 n6 n7 3645.83333333 RPP
R7 n7 n8 3645.83333333 RPP
R8 n8 n9 3645.83333333 RPP
R9 n9 n10 3645.83333333 RPP
R10 n10 n11 3645.83333333 RPP
R11 n11 n12 3645.83333333 RPP
R12 n12 n13 3645.83333333 RPP
R13 n13 n14 3645.83333333 RPP
R14 n14 n15 3645.83333333 RPP
R15 n15 n16 3645.83333333 RPP
R16 n16 n17 3645.83333333 RPP
R17 n17 n18 3645.83333333 RPP
R18 n18 n19 3645.83333333 RPP
R19 n19 n20 3645.83333333 RPP
R20 n20 n21 3645.83333333 RPP
R21 n21 n22 3645.83333333 RPP
R22 n22 n23 3645.83333333 RPP
R23 n23 n24 3645.83333333 RPP
R24 n24 n25 3645.83333333 RPP
R25 n25 n26 3645.83333333 RPP
R26 n26 n27 3645.83333333 RPP
R27 n27 n28 3645.83333333 RPP
R28 n28 n29 3645.83333333 RPP
R29 n29 n30 3645.83333333 RPP
R30 n30 n31 3645.83333333 RPP
R31 n31 B 3645.83333333 RPP
.ends bias_XRT

.subckt bias_XRB A B
R0 A n1 3645.83333333 RPP
R1 n1 n2 3645.83333333 RPP
R2 n2 n3 3645.83333333 RPP
R3 n3 n4 3645.83333333 RPP
R4 n4 n5 3645.83333333 RPP
R5 n5 n6 3645.83333333 RPP
R6 n6 n7 3645.83333333 RPP
R7 n7 n8 3645.83333333 RPP
R8 n8 n9 3645.83333333 RPP
R9 n9 n10 3645.83333333 RPP
R10 n10 n11 3645.83333333 RPP
R11 n11 n12 3645.83333333 RPP
R12 n12 n13 3645.83333333 RPP
R13 n13 n14 3645.83333333 RPP
R14 n14 n15 3645.83333333 RPP
R15 n15 n16 3645.83333333 RPP
R16 n16 n17 3645.83333333 RPP
R17 n17 n18 3645.83333333 RPP
R18 n18 n19 3645.83333333 RPP
R19 n19 n20 3645.83333333 RPP
R20 n20 n21 3645.83333333 RPP
R21 n21 n22 3645.83333333 RPP
R22 n22 n23 3645.83333333 RPP
R23 n23 n24 3645.83333333 RPP
R24 n24 n25 3645.83333333 RPP
R25 n25 n26 3645.83333333 RPP
R26 n26 n27 3645.83333333 RPP
R27 n27 n28 3645.83333333 RPP
R28 n28 n29 3645.83333333 RPP
R29 n29 n30 3645.83333333 RPP
R30 n30 n31 3645.83333333 RPP
R31 n31 n32 3645.83333333 RPP
R32 n32 n33 3645.83333333 RPP
R33 n33 n34 3645.83333333 RPP
R34 n34 n35 3645.83333333 RPP
R35 n35 n36 3645.83333333 RPP
R36 n36 n37 3645.83333333 RPP
R37 n37 n38 3645.83333333 RPP
R38 n38 n39 3645.83333333 RPP
R39 n39 n40 3645.83333333 RPP
R40 n40 n41 3645.83333333 RPP
R41 n41 n42 3645.83333333 RPP
R42 n42 n43 3645.83333333 RPP
R43 n43 n44 3645.83333333 RPP
R44 n44 n45 3645.83333333 RPP
R45 n45 n46 3645.83333333 RPP
R46 n46 n47 3645.83333333 RPP
R47 n47 n48 3645.83333333 RPP
R48 n48 n49 3645.83333333 RPP
R49 n49 n50 3645.83333333 RPP
R50 n50 n51 3645.83333333 RPP
R51 n51 n52 3645.83333333 RPP
R52 n52 n53 3645.83333333 RPP
R53 n53 n54 3645.83333333 RPP
R54 n54 n55 3645.83333333 RPP
R55 n55 n56 3645.83333333 RPP
R56 n56 n57 3645.83333333 RPP
R57 n57 n58 3645.83333333 RPP
R58 n58 n59 3645.83333333 RPP
R59 n59 n60 3645.83333333 RPP
R60 n60 n61 3645.83333333 RPP
R61 n61 n62 3645.83333333 RPP
R62 n62 n63 3645.83333333 RPP
R63 n63 n64 3645.83333333 RPP
R64 n64 n65 3645.83333333 RPP
R65 n65 n66 3645.83333333 RPP
R66 n66 n67 3645.83333333 RPP
R67 n67 n68 3645.83333333 RPP
R68 n68 n69 3645.83333333 RPP
R69 n69 n70 3645.83333333 RPP
R70 n70 n71 3645.83333333 RPP
R71 n71 n72 3645.83333333 RPP
R72 n72 n73 3645.83333333 RPP
R73 n73 n74 3645.83333333 RPP
R74 n74 n75 3645.83333333 RPP
R75 n75 n76 3645.83333333 RPP
R76 n76 n77 3645.83333333 RPP
R77 n77 n78 3645.83333333 RPP
R78 n78 n79 3645.83333333 RPP
R79 n79 n80 3645.83333333 RPP
R80 n80 n81 3645.83333333 RPP
R81 n81 n82 3645.83333333 RPP
R82 n82 n83 3645.83333333 RPP
R83 n83 n84 3645.83333333 RPP
R84 n84 n85 3645.83333333 RPP
R85 n85 n86 3645.83333333 RPP
R86 n86 n87 3645.83333333 RPP
R87 n87 n88 3645.83333333 RPP
R88 n88 n89 3645.83333333 RPP
R89 n89 n90 3645.83333333 RPP
R90 n90 n91 3645.83333333 RPP
R91 n91 n92 3645.83333333 RPP
R92 n92 n93 3645.83333333 RPP
R93 n93 n94 3645.83333333 RPP
R94 n94 n95 3645.83333333 RPP
R95 n95 n96 3645.83333333 RPP
R96 n96 n97 3645.83333333 RPP
R97 n97 n98 3645.83333333 RPP
R98 n98 n99 3645.83333333 RPP
R99 n99 n100 3645.83333333 RPP
R100 n100 n101 3645.83333333 RPP
R101 n101 n102 3645.83333333 RPP
R102 n102 n103 3645.83333333 RPP
R103 n103 n104 3645.83333333 RPP
R104 n104 n105 3645.83333333 RPP
R105 n105 n106 3645.83333333 RPP
R106 n106 n107 3645.83333333 RPP
R107 n107 n108 3645.83333333 RPP
R108 n108 n109 3645.83333333 RPP
R109 n109 n110 3645.83333333 RPP
R110 n110 n111 3645.83333333 RPP
R111 n111 n112 3645.83333333 RPP
R112 n112 n113 3645.83333333 RPP
R113 n113 n114 3645.83333333 RPP
R114 n114 n115 3645.83333333 RPP
R115 n115 n116 3645.83333333 RPP
R116 n116 n117 3645.83333333 RPP
R117 n117 n118 3645.83333333 RPP
R118 n118 n119 3645.83333333 RPP
R119 n119 n120 3645.83333333 RPP
R120 n120 n121 3645.83333333 RPP
R121 n121 n122 3645.83333333 RPP
R122 n122 n123 3645.83333333 RPP
R123 n123 n124 3645.83333333 RPP
R124 n124 n125 3645.83333333 RPP
R125 n125 n126 3645.83333333 RPP
R126 n126 n127 3645.83333333 RPP
R127 n127 n128 3645.83333333 RPP
R128 n128 n129 3645.83333333 RPP
R129 n129 n130 3645.83333333 RPP
R130 n130 n131 3645.83333333 RPP
R131 n131 n132 3645.83333333 RPP
R132 n132 n133 3645.83333333 RPP
R133 n133 n134 3645.83333333 RPP
R134 n134 n135 3645.83333333 RPP
R135 n135 n136 3645.83333333 RPP
R136 n136 n137 3645.83333333 RPP
R137 n137 n138 3645.83333333 RPP
R138 n138 n139 3645.83333333 RPP
R139 n139 n140 3645.83333333 RPP
R140 n140 n141 3645.83333333 RPP
R141 n141 n142 3645.83333333 RPP
R142 n142 n143 3645.83333333 RPP
R143 n143 n144 3645.83333333 RPP
R144 n144 n145 3645.83333333 RPP
R145 n145 n146 3645.83333333 RPP
R146 n146 n147 3645.83333333 RPP
R147 n147 n148 3645.83333333 RPP
R148 n148 n149 3645.83333333 RPP
R149 n149 n150 3645.83333333 RPP
R150 n150 n151 3645.83333333 RPP
R151 n151 n152 3645.83333333 RPP
R152 n152 n153 3645.83333333 RPP
R153 n153 n154 3645.83333333 RPP
R154 n154 n155 3645.83333333 RPP
R155 n155 n156 3645.83333333 RPP
R156 n156 n157 3645.83333333 RPP
R157 n157 n158 3645.83333333 RPP
R158 n158 n159 3645.83333333 RPP
R159 n159 B 3645.83333333 RPP
.ends bias_XRB

.subckt bias_XRSET A B
R0 A n1 3645.83333333 RPP
R1 n1 n2 3645.83333333 RPP
R2 n2 n3 3645.83333333 RPP
R3 n3 n4 3645.83333333 RPP
R4 n4 n5 3645.83333333 RPP
R5 n5 n6 3645.83333333 RPP
R6 n6 n7 3645.83333333 RPP
R7 n7 n8 3645.83333333 RPP
R8 n8 n9 3645.83333333 RPP
R9 n9 n10 3645.83333333 RPP
R10 n10 n11 3645.83333333 RPP
R11 n11 n12 3645.83333333 RPP
R12 n12 n13 3645.83333333 RPP
R13 n13 n14 3645.83333333 RPP
R14 n14 n15 3645.83333333 RPP
R15 n15 n16 3645.83333333 RPP
R16 n16 n17 3645.83333333 RPP
R17 n17 n18 3645.83333333 RPP
R18 n18 n19 3645.83333333 RPP
R19 n19 n20 3645.83333333 RPP
R20 n20 n21 3645.83333333 RPP
R21 n21 n22 3645.83333333 RPP
R22 n22 n23 3645.83333333 RPP
R23 n23 n24 3645.83333333 RPP
R24 n24 n25 3645.83333333 RPP
R25 n25 n26 3645.83333333 RPP
R26 n26 n27 3645.83333333 RPP
R27 n27 n28 3645.83333333 RPP
R28 n28 n29 3645.83333333 RPP
R29 n29 n30 3645.83333333 RPP
R30 n30 n31 3645.83333333 RPP
R31 n31 n32 3645.83333333 RPP
R32 n32 n33 3645.83333333 RPP
R33 n33 n34 3645.83333333 RPP
R34 n34 n35 3645.83333333 RPP
R35 n35 n36 3645.83333333 RPP
R36 n36 n37 3645.83333333 RPP
R37 n37 n38 3645.83333333 RPP
R38 n38 n39 3645.83333333 RPP
R39 n39 n40 3645.83333333 RPP
R40 n40 n41 3645.83333333 RPP
R41 n41 n42 3645.83333333 RPP
R42 n42 n43 3645.83333333 RPP
R43 n43 n44 3645.83333333 RPP
R44 n44 n45 3645.83333333 RPP
R45 n45 n46 3645.83333333 RPP
R46 n46 n47 3645.83333333 RPP
R47 n47 n48 3645.83333333 RPP
R48 n48 n49 3645.83333333 RPP
R49 n49 n50 3645.83333333 RPP
R50 n50 n51 3645.83333333 RPP
R51 n51 n52 3645.83333333 RPP
R52 n52 n53 3645.83333333 RPP
R53 n53 n54 3645.83333333 RPP
R54 n54 n55 3645.83333333 RPP
R55 n55 n56 3645.83333333 RPP
R56 n56 n57 3645.83333333 RPP
R57 n57 n58 3645.83333333 RPP
R58 n58 n59 3645.83333333 RPP
R59 n59 n60 3645.83333333 RPP
R60 n60 n61 3645.83333333 RPP
R61 n61 n62 3645.83333333 RPP
R62 n62 n63 3645.83333333 RPP
R63 n63 n64 3645.83333333 RPP
R64 n64 n65 3645.83333333 RPP
R65 n65 n66 3645.83333333 RPP
R66 n66 n67 3645.83333333 RPP
R67 n67 n68 3645.83333333 RPP
R68 n68 n69 3645.83333333 RPP
R69 n69 n70 3645.83333333 RPP
R70 n70 n71 3645.83333333 RPP
R71 n71 n72 3645.83333333 RPP
R72 n72 n73 3645.83333333 RPP
R73 n73 n74 3645.83333333 RPP
R74 n74 n75 3645.83333333 RPP
R75 n75 n76 3645.83333333 RPP
R76 n76 n77 3645.83333333 RPP
R77 n77 n78 3645.83333333 RPP
R78 n78 n79 3645.83333333 RPP
R79 n79 n80 3645.83333333 RPP
R80 n80 n81 3645.83333333 RPP
R81 n81 n82 3645.83333333 RPP
R82 n82 n83 3645.83333333 RPP
R83 n83 n84 3645.83333333 RPP
R84 n84 n85 3645.83333333 RPP
R85 n85 n86 3645.83333333 RPP
R86 n86 n87 3645.83333333 RPP
R87 n87 n88 3645.83333333 RPP
R88 n88 n89 3645.83333333 RPP
R89 n89 n90 3645.83333333 RPP
R90 n90 n91 3645.83333333 RPP
R91 n91 n92 3645.83333333 RPP
R92 n92 n93 3645.83333333 RPP
R93 n93 n94 3645.83333333 RPP
R94 n94 n95 3645.83333333 RPP
R95 n95 n96 3645.83333333 RPP
R96 n96 n97 3645.83333333 RPP
R97 n97 n98 3645.83333333 RPP
R98 n98 n99 3645.83333333 RPP
R99 n99 n100 3645.83333333 RPP
R100 n100 n101 3645.83333333 RPP
R101 n101 n102 3645.83333333 RPP
R102 n102 n103 3645.83333333 RPP
R103 n103 n104 3645.83333333 RPP
R104 n104 n105 3645.83333333 RPP
R105 n105 n106 3645.83333333 RPP
R106 n106 n107 3645.83333333 RPP
R107 n107 n108 3645.83333333 RPP
R108 n108 n109 3645.83333333 RPP
R109 n109 n110 3645.83333333 RPP
R110 n110 n111 3645.83333333 RPP
R111 n111 n112 3645.83333333 RPP
R112 n112 n113 3645.83333333 RPP
R113 n113 n114 3645.83333333 RPP
R114 n114 n115 3645.83333333 RPP
R115 n115 n116 3645.83333333 RPP
R116 n116 n117 3645.83333333 RPP
R117 n117 n118 3645.83333333 RPP
R118 n118 n119 3645.83333333 RPP
R119 n119 n120 3645.83333333 RPP
R120 n120 n121 3645.83333333 RPP
R121 n121 n122 3645.83333333 RPP
R122 n122 n123 3645.83333333 RPP
R123 n123 n124 3645.83333333 RPP
R124 n124 n125 3645.83333333 RPP
R125 n125 n126 3645.83333333 RPP
R126 n126 n127 3645.83333333 RPP
R127 n127 n128 3645.83333333 RPP
R128 n128 n129 3645.83333333 RPP
R129 n129 n130 3645.83333333 RPP
R130 n130 n131 3645.83333333 RPP
R131 n131 n132 3645.83333333 RPP
R132 n132 n133 3645.83333333 RPP
R133 n133 n134 3645.83333333 RPP
R134 n134 n135 3645.83333333 RPP
R135 n135 n136 3645.83333333 RPP
R136 n136 n137 3645.83333333 RPP
R137 n137 n138 3645.83333333 RPP
R138 n138 n139 3645.83333333 RPP
R139 n139 n140 3645.83333333 RPP
R140 n140 n141 3645.83333333 RPP
R141 n141 n142 3645.83333333 RPP
R142 n142 n143 3645.83333333 RPP
R143 n143 n144 3645.83333333 RPP
R144 n144 n145 3645.83333333 RPP
R145 n145 n146 3645.83333333 RPP
R146 n146 n147 3645.83333333 RPP
R147 n147 n148 3645.83333333 RPP
R148 n148 n149 3645.83333333 RPP
R149 n149 n150 3645.83333333 RPP
R150 n150 n151 3645.83333333 RPP
R151 n151 n152 3645.83333333 RPP
R152 n152 n153 3645.83333333 RPP
R153 n153 n154 3645.83333333 RPP
R154 n154 n155 3645.83333333 RPP
R155 n155 n156 3645.83333333 RPP
R156 n156 n157 3645.83333333 RPP
R157 n157 n158 3645.83333333 RPP
R158 n158 n159 3645.83333333 RPP
R159 n159 B 3645.83333333 RPP
.ends bias_XRSET

.subckt bias_XRP A B
R0 A n1 3645.83333333 RPP
R1 n1 n2 3645.83333333 RPP
R2 n2 n3 3645.83333333 RPP
R3 n3 n4 3645.83333333 RPP
R4 n4 n5 3645.83333333 RPP
R5 n5 n6 3645.83333333 RPP
R6 n6 n7 3645.83333333 RPP
R7 n7 n8 3645.83333333 RPP
R8 n8 n9 3645.83333333 RPP
R9 n9 n10 3645.83333333 RPP
R10 n10 n11 3645.83333333 RPP
R11 n11 n12 3645.83333333 RPP
R12 n12 n13 3645.83333333 RPP
R13 n13 n14 3645.83333333 RPP
R14 n14 n15 3645.83333333 RPP
R15 n15 n16 3645.83333333 RPP
R16 n16 n17 3645.83333333 RPP
R17 n17 n18 3645.83333333 RPP
R18 n18 n19 3645.83333333 RPP
R19 n19 n20 3645.83333333 RPP
R20 n20 n21 3645.83333333 RPP
R21 n21 n22 3645.83333333 RPP
R22 n22 n23 3645.83333333 RPP
R23 n23 n24 3645.83333333 RPP
R24 n24 n25 3645.83333333 RPP
R25 n25 n26 3645.83333333 RPP
R26 n26 n27 3645.83333333 RPP
R27 n27 n28 3645.83333333 RPP
R28 n28 n29 3645.83333333 RPP
R29 n29 n30 3645.83333333 RPP
R30 n30 n31 3645.83333333 RPP
R31 n31 n32 3645.83333333 RPP
R32 n32 n33 3645.83333333 RPP
R33 n33 n34 3645.83333333 RPP
R34 n34 n35 3645.83333333 RPP
R35 n35 n36 3645.83333333 RPP
R36 n36 n37 3645.83333333 RPP
R37 n37 n38 3645.83333333 RPP
R38 n38 n39 3645.83333333 RPP
R39 n39 n40 3645.83333333 RPP
R40 n40 n41 3645.83333333 RPP
R41 n41 n42 3645.83333333 RPP
R42 n42 n43 3645.83333333 RPP
R43 n43 n44 3645.83333333 RPP
R44 n44 n45 3645.83333333 RPP
R45 n45 n46 3645.83333333 RPP
R46 n46 n47 3645.83333333 RPP
R47 n47 n48 3645.83333333 RPP
R48 n48 n49 3645.83333333 RPP
R49 n49 n50 3645.83333333 RPP
R50 n50 n51 3645.83333333 RPP
R51 n51 n52 3645.83333333 RPP
R52 n52 n53 3645.83333333 RPP
R53 n53 n54 3645.83333333 RPP
R54 n54 n55 3645.83333333 RPP
R55 n55 n56 3645.83333333 RPP
R56 n56 n57 3645.83333333 RPP
R57 n57 n58 3645.83333333 RPP
R58 n58 n59 3645.83333333 RPP
R59 n59 n60 3645.83333333 RPP
R60 n60 n61 3645.83333333 RPP
R61 n61 n62 3645.83333333 RPP
R62 n62 n63 3645.83333333 RPP
R63 n63 n64 3645.83333333 RPP
R64 n64 n65 3645.83333333 RPP
R65 n65 n66 3645.83333333 RPP
R66 n66 n67 3645.83333333 RPP
R67 n67 n68 3645.83333333 RPP
R68 n68 n69 3645.83333333 RPP
R69 n69 n70 3645.83333333 RPP
R70 n70 n71 3645.83333333 RPP
R71 n71 n72 3645.83333333 RPP
R72 n72 n73 3645.83333333 RPP
R73 n73 n74 3645.83333333 RPP
R74 n74 n75 3645.83333333 RPP
R75 n75 n76 3645.83333333 RPP
R76 n76 n77 3645.83333333 RPP
R77 n77 n78 3645.83333333 RPP
R78 n78 n79 3645.83333333 RPP
R79 n79 n80 3645.83333333 RPP
R80 n80 n81 3645.83333333 RPP
R81 n81 n82 3645.83333333 RPP
R82 n82 n83 3645.83333333 RPP
R83 n83 n84 3645.83333333 RPP
R84 n84 n85 3645.83333333 RPP
R85 n85 n86 3645.83333333 RPP
R86 n86 n87 3645.83333333 RPP
R87 n87 n88 3645.83333333 RPP
R88 n88 n89 3645.83333333 RPP
R89 n89 n90 3645.83333333 RPP
R90 n90 n91 3645.83333333 RPP
R91 n91 n92 3645.83333333 RPP
R92 n92 n93 3645.83333333 RPP
R93 n93 n94 3645.83333333 RPP
R94 n94 n95 3645.83333333 RPP
R95 n95 n96 3645.83333333 RPP
R96 n96 n97 3645.83333333 RPP
R97 n97 n98 3645.83333333 RPP
R98 n98 n99 3645.83333333 RPP
R99 n99 n100 3645.83333333 RPP
R100 n100 n101 3645.83333333 RPP
R101 n101 n102 3645.83333333 RPP
R102 n102 n103 3645.83333333 RPP
R103 n103 n104 3645.83333333 RPP
R104 n104 n105 3645.83333333 RPP
R105 n105 n106 3645.83333333 RPP
R106 n106 n107 3645.83333333 RPP
R107 n107 n108 3645.83333333 RPP
R108 n108 n109 3645.83333333 RPP
R109 n109 n110 3645.83333333 RPP
R110 n110 n111 3645.83333333 RPP
R111 n111 n112 3645.83333333 RPP
R112 n112 n113 3645.83333333 RPP
R113 n113 n114 3645.83333333 RPP
R114 n114 n115 3645.83333333 RPP
R115 n115 n116 3645.83333333 RPP
R116 n116 n117 3645.83333333 RPP
R117 n117 n118 3645.83333333 RPP
R118 n118 n119 3645.83333333 RPP
R119 n119 n120 3645.83333333 RPP
R120 n120 n121 3645.83333333 RPP
R121 n121 n122 3645.83333333 RPP
R122 n122 n123 3645.83333333 RPP
R123 n123 n124 3645.83333333 RPP
R124 n124 n125 3645.83333333 RPP
R125 n125 n126 3645.83333333 RPP
R126 n126 n127 3645.83333333 RPP
R127 n127 n128 3645.83333333 RPP
R128 n128 n129 3645.83333333 RPP
R129 n129 n130 3645.83333333 RPP
R130 n130 n131 3645.83333333 RPP
R131 n131 n132 3645.83333333 RPP
R132 n132 n133 3645.83333333 RPP
R133 n133 n134 3645.83333333 RPP
R134 n134 n135 3645.83333333 RPP
R135 n135 B 3645.83333333 RPP
.ends bias_XRP

.subckt capsense_current_bias REF VDD VSS VBN VBP IREF
XMOS REF VDD VSS VBN VBP IREF NB BN_FB SENSE capsense_bias_mos
XXRBIAS VDD NB bias_XRBIAS
XXRT VBN BN_FB bias_XRT
XXRB BN_FB VSS bias_XRB
XXRSET SENSE VSS bias_XRSET
XXRP VDD VBP bias_XRP
.ends capsense_current_bias

.subckt Bias REF VDD VSS VBN VBP IREF
XCORE REF VDD VSS VBN VBP IREF capsense_current_bias
.ends Bias
.subckt CapSense_ASIC_CONNECTED PAD1 PAD2 PAD3 PAD4 PAD5 PAD6 PAD7 PAD8 PAD9 PAD10 PAD11 PAD12 PAD13 PAD14 PAD15 PAD16 PAD17 PAD18 PAD19 PAD20 PAD21 PAD22 PAD23 PAD24 PAD25 PAD26 PAD27 PAD28 PAD29 PAD30 PAD31 PAD32 VDD GROUND
XPADS PAD1 PAD2 PAD3 PAD4 PAD5 PAD6 PAD7 PAD8 PAD9 PAD10 PAD11 PAD12 PAD13 PAD14 PAD15 PAD16 PAD17 PAD18 PAD19 PAD20 PAD21 PAD22 PAD23 PAD24 PAD25 PAD26 PAD27 PAD28 PAD29 PAD30 PAD31 PAD32 PAD2_OUT PAD4_OUT PAD6_OUT PAD8_OUT PAD10_OUT PAD12_OUT PAD14_OUT PAD16_OUT PAD18_OUT PAD20_OUT PAD22_OUT PAD24_OUT PAD26_OUT PAD28_OUT PAD30_OUT PAD32_OUT VDD GROUND frame4mmx4mm
XOTA SUMN SUMP PAD1 PAD3 VDD GROUND BIAS PAD7 VBN VBP OTA
XSwitch_cap VDD GROUND PAD11 PAD5 SENSN TXP TXN RXP RXN SUMP SUMN PAD1 PAD3 PHI1 PHI1B PHIT PHITB PHI2 PHI2B Switch_cap
XInput_VCM_bias_stabilizer SUMP SUMN VDD GROUND PAD7 PHI1 PHIT PHI2 PAD2_OUT SAMPLE_VALID_CORE PAD4_OUT Input_VCM_bias_stabilizer
XBias PAD7 VDD GROUND VBN VBP BIAS Bias
XPhase_generator GROUND VDD PAD2_OUT PHI1 PHI1B PHI2 PHI2B PHIT PHITB PAD4_OUT SAMPLE_VALID_CORE capsense_phase_gen
XADC_valid_buffer SAMPLE_VALID_CORE PAD9 GROUND VDD BUFF00
.ends CapSense_ASIC_CONNECTED
