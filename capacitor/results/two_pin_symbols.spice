** sch_path: capacitor/results/two_pin_symbols.sch
**.subckt two_pin_symbols
XC0 top0 0 scl08_cap_gnd_2.5p
R0 drive top0 1meg m=1
XC1 top1 0 scl08_cap_gnd_7.5p
R1 drive top1 1meg m=1
XC2 top2 0 scl08_cap_gnd_3p
R2 drive top2 1meg m=1
VIN drive 0 pulse(0 1 1u 1n 1n 80u 160u)
**** begin user architecture code

.include ../models/generated_caps.lib.spice

.control
set filetype=binary
tran 5n 100u
write two_pin_symbols.raw v(drive) v(top0) v(top1) v(top2)
quit
.endc

**** end user architecture code
**.ends
.end
