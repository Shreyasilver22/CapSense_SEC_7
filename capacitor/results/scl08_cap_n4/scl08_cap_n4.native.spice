* NGSPICE file created from scl08_cap_n4.ext - technology: SCL_CP8D

.subckt scl08_cap_n4 BOT TOP
C0 BOT TOP 45.536000fF
C1 TOP 0 30.240000fF
.ends
