* NGSPICE file created from scl08_cap_n2.ext - technology: SCL_CP8D

.subckt scl08_cap_n2 BOT TOP
C0 BOT TOP 22.768000fF
C1 TOP 0 16.640000fF
.ends
