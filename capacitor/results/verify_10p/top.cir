Check extracted alias for 10p
.include "../../models/generated_caps.lib.spice"
VTOP top 0 dc 0 ac 1
VBOT bot 0 0
VSUB sub 0 0
XC top bot sub scl08_cap_10p
.control
set wr_singlescale
set wr_vecnames
ac dec 10 1meg 2meg
let cm=abs(imag(i(VBOT)))/(2*PI*frequency)
let ct=abs(imag(i(VSUB)))/(2*PI*frequency)
wrdata top.dat real(cm) real(ct)
quit
.endc
.end
