* NGSPICE file created from scl08_cap_n1.ext - technology: SCL_CP8D

.subckt scl08_cap_n1 BOT TOP
C0 BOT TOP 11.384000fF
C1 TOP 0 3.856000fF
.ends
