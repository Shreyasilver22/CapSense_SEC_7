* NGSPICE file created from scl08_cap_n351.ext - technology: SCL_CP8D

.subckt scl08_cap_n351 BOT TOP
C0 BOT TOP 3995.780000fF
C1 TOP 0 2446.960000fF
.ends
