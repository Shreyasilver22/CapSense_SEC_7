* NGSPICE file created from capopt_compact_3p.ext - technology: SCL_CP8D

.subckt capopt_compact_3p BOT TOP
C0 BOT TOP 3004.570000fF
C1 TOP 0 1600.500000fF
.ends
