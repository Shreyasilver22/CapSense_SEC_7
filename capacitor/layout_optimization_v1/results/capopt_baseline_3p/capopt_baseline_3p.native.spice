* NGSPICE file created from capopt_baseline_3p.ext - technology: SCL_CP8D

.subckt capopt_baseline_3p BOT TOP
C0 BOT TOP 3005.380000fF
C1 TOP 0 1851.550000fF
.ends
