* NGSPICE file created from capopt_slotted_4p.ext - technology: SCL_CP8D

.subckt capopt_slotted_4p BOT TOP
C0 BOT TOP 3995.740000fF
C1 TOP 0 615.322000fF
.ends
