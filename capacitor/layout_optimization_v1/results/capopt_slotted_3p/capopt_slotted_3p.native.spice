* NGSPICE file created from capopt_slotted_3p.ext - technology: SCL_CP8D

.subckt capopt_slotted_3p BOT TOP
C0 BOT TOP 3005.390000fF
C1 TOP 0 468.898000fF
.ends
