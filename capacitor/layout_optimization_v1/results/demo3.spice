** sch_path: capacitor/layout_optimization_v1/examples/layout_comparison.sch
**.subckt layout_comparison
XC0 top0 0 0 capopt_baseline_4p
R0 drive top0 1meg m=1
XC1 top1 0 0 capopt_compact_4p
R1 drive top1 1meg m=1
XC2 top2 0 0 capopt_slotted_4p
R2 drive top2 1meg m=1
VIN drive 0 pulse(0 1 1u 1n 1n 80u 160u)
**** begin user architecture code

.include ../models/cap_layouts.lib.spice

.control
set filetype=binary
tran 5n 100u
write demo3.raw v(drive) v(top0) v(top1) v(top2)
quit
.endc

**** end user architecture code
**.ends
.end
