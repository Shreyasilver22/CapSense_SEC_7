* NGSPICE file created from capopt_baseline_4p.ext - technology: SCL_CP8D

.subckt capopt_baseline_4p BOT TOP
C0 BOT TOP 3995.780000fF
C1 TOP 0 2446.960000fF
.ends
