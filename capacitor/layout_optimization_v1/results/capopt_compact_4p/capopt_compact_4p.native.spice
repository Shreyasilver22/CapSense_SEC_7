* NGSPICE file created from capopt_compact_4p.ext - technology: SCL_CP8D

.subckt capopt_compact_4p BOT TOP
C0 BOT TOP 3990.980000fF
C1 TOP 0 2115.850000fF
.ends
