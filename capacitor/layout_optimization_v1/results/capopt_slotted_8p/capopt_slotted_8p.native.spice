* NGSPICE file created from capopt_slotted_8p.ext - technology: SCL_CP8D

.subckt capopt_slotted_8p BOT TOP
C0 BOT TOP 8002.910000fF
C1 TOP 0 1210.030000fF
.ends
