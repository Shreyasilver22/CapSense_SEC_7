* NGSPICE file created from capopt_compact_8p.ext - technology: SCL_CP8D

.subckt capopt_compact_8p BOT TOP
C0 BOT TOP 8004.630000fF
C1 TOP 0 4240.630000fF
.ends
