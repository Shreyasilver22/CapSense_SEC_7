* NGSPICE file created from ota_telescopic_layout.ext - technology: SCL_CP8D

.subckt ota_telescopic_layout INP INN OUTP OUTM VDD VSS IREF VCM VBN VBP
M1000 a_153000_515500# a_264600_458100# VDD VDD P w=20u l=3.2u
+  ad=90.00001p pd=49u as=90.00001p ps=49u
M1001 OUTP a_153000_515500# OUTP OUTP P w=20u l=10u
+  ad=90.00001p pd=49u as=1.71n ps=0.913m
M1002 a_153000_458100# IREF VSS VSS N w=11.429u l=3.2u
+  ad=51.4305p pd=31.858u as=51.4305p ps=31.858u
M1003 OUTM a_153000_515500# OUTM OUTM P w=20u l=10u
+  ad=90.00001p pd=49u as=1.71n ps=0.913m
M1004 a_148500_363000# a_153000_458100# VDD VDD P w=40u l=3.2u
+  ad=0.18n pd=89u as=0.18n ps=89u
M1005 OUTM a_153000_515500# OUTM OUTM P w=20u l=10u
+  ad=90.00001p pd=49u as=0 ps=0
M1006 a_192600_71400# INP a_156200_71400# VSS N w=15u l=2.4u
+  ad=67.50001p pd=39u as=67.50001p ps=39u
M1007 OUTP a_153000_515500# OUTP OUTP P w=20u l=10u
+  ad=90.00001p pd=49u as=0 ps=0
M1008 OUTM a_153000_515500# OUTM OUTM P w=20u l=10u
+  ad=90.00001p pd=49u as=0 ps=0
M1009 OUTP a_153000_515500# OUTP OUTP P w=20u l=10u
+  ad=90.00001p pd=49u as=0 ps=0
M1010 VDD a_153000_515500# VDD VDD P w=20u l=10u
+  ad=90.00001p pd=49u as=1.89n ps=0.984m
M1011 VSS OUTM a_229000_363000# VDD P w=40u l=1.6u
+  ad=0.18n pd=89u as=0.18n ps=89u
M1012 OUTP a_153000_515500# OUTP OUTP P w=20u l=10u
+  ad=90.00001p pd=49u as=0 ps=0
M1013 a_153000_458100# a_153000_458100# VDD VDD P w=20u l=3.2u
+  ad=90.00001p pd=49u as=90.00001p ps=49u
M1014 OUTM VBN a_192600_71400# VSS N w=30u l=2.4u
+  ad=0.135n pd=69u as=0.135n ps=69u
M1015 a_264600_458100# a_151400_1341400# a_230600_459600# VSS N w=10u l=2.4u
+  ad=45p pd=29u as=45p ps=29u
M1016 OUTP VBN a_229000_71400# VSS N w=30u l=2.4u
+  ad=0.135n pd=69u as=0.135n ps=69u
M1017 a_153000_515500# a_148500_363000# a_230600_459600# VSS N w=10u l=2.4u
+  ad=45p pd=29u as=45p ps=29u
M1018 VSS OUTP a_151400_747400# VDD P w=40u l=1.6u
+  ad=0.18n pd=89u as=0.18n ps=89u
M1019 a_156200_71400# IREF VSS VSS N w=80.00001u l=3.2u
+  ad=0.36n pd=0.169m as=0.36n ps=0.169m
M1020 OUTM a_153000_515500# OUTM OUTM P w=20u l=10u
+  ad=90.00001p pd=49u as=0 ps=0
M1021 OUTP a_153000_515500# OUTP OUTP P w=20u l=10u
+  ad=90.00001p pd=49u as=0 ps=0
M1022 a_151400_747400# a_153000_458100# VDD VDD P w=40u l=3.2u
+  ad=0.18n pd=89u as=0.18n ps=89u
M1023 OUTP VBP a_148500_227200# VDD P w=60u l=2.4u
+  ad=0.27n pd=0.129m as=0.27n ps=0.129m
M1024 VDD a_153000_515500# VDD VDD P w=20u l=10u
+  ad=90.00001p pd=49u as=0 ps=0
M1025 a_192600_227200# a_153000_515500# VDD VDD P w=40u l=3.2u
+  ad=0.18n pd=89u as=0.18n ps=89u
M1026 OUTM VBP a_192600_227200# VDD P w=60u l=2.4u
+  ad=0.27n pd=0.129m as=0.27n ps=0.129m
M1027 VDD a_153000_515500# VDD VDD P w=20u l=10u
+  ad=90.00001p pd=49u as=0 ps=0
M1028 IREF IREF VSS VSS N w=20u l=3.2u
+  ad=90.00001p pd=49u as=90.00001p ps=49u
M1029 a_264600_458100# a_264600_458100# VDD VDD P w=20u l=3.2u
+  ad=90.00001p pd=49u as=90.00001p ps=49u
M1030 VSS VCM a_148500_363000# VDD P w=40u l=1.6u
+  ad=0.18n pd=89u as=0.18n ps=89u
M1031 a_230600_459600# IREF VSS VSS N w=11.429u l=3.2u
+  ad=51.4305p pd=31.858u as=51.4305p ps=31.858u
M1032 a_229000_363000# a_153000_458100# VDD VDD P w=40u l=3.2u
+  ad=0.18n pd=89u as=0.18n ps=89u
M1033 OUTM a_153000_515500# OUTM OUTM P w=20u l=10u
+  ad=90.00001p pd=49u as=0 ps=0
M1034 OUTP a_153000_515500# OUTP OUTP P w=20u l=10u
+  ad=90.00001p pd=49u as=0 ps=0
M1035 a_148500_227200# a_153000_515500# VDD VDD P w=40u l=3.2u
+  ad=0.18n pd=89u as=0.18n ps=89u
M1036 a_229000_71400# INN a_156200_71400# VSS N w=15u l=2.4u
+  ad=67.50001p pd=39u as=67.50001p ps=39u
M1037 OUTM a_153000_515500# OUTM OUTM P w=20u l=10u
+  ad=90.00001p pd=49u as=0 ps=0
M1038 OUTM a_153000_515500# OUTM OUTM P w=20u l=10u
+  ad=90.00001p pd=49u as=0 ps=0
M1039 VDD a_153000_515500# VDD VDD P w=20u l=10u
+  ad=90.00001p pd=49u as=0 ps=0
M1040 OUTM a_153000_515500# OUTM OUTM P w=20u l=10u
+  ad=90.00001p pd=49u as=0 ps=0
M1041 OUTP a_153000_515500# OUTP OUTP P w=20u l=10u
+  ad=90.00001p pd=49u as=0 ps=0
M1042 OUTP a_153000_515500# OUTP OUTP P w=20u l=10u
+  ad=90.00001p pd=49u as=0 ps=0
C0 a_155000_1269400# a_1012143_1263400# 0.05819f
C1 a_1043543_1209400# a_1043543_1197400# 0
C2 a_1904286_855400# a_1904286_843400# 0
C3 a_155000_789400# a_1012143_783400# 0.05819f
C4 a_1012143_1083400# a_1012143_1071400# 0
C5 a_1904286_1083400# a_1047143_1083400# 0.05819f
C6 a_151400_747400# VBP 0.28651f
C7 a_1043543_1017400# a_1047143_1023400# 0.05819f
C8 a_1012143_1311400# a_155000_1311400# 0.05819f
C9 a_151400_957400# a_151400_945400# 0
C10 a_1043543_957400# a_1047143_957400# 0.05819f
C11 a_151400_1245400# a_155000_1251400# 0.05819f
C12 a_151400_1185400# a_155000_1185400# 0.05819f
C13 a_1012143_831400# a_155000_831400# 0.05819f
C14 a_151400_765400# a_155000_771400# 0.05819f
C15 a_1047143_1005400# a_1904286_999400# 0.05819f
C16 a_192600_71400# OUTP 0.28651f
C17 a_1904286_1299400# a_1904286_1287400# 0
C18 a_155000_1233400# a_1012143_1227400# 0.05819f
C19 a_1043543_1173400# a_1043543_1161400# 0
C20 a_1904286_819400# a_1904286_807400# 0
C21 a_155000_753400# a_1012143_747400# 0.05819f
C22 a_1012143_1047400# a_1012143_1035400# 0
C23 a_1904286_1047400# a_1047143_1047400# 0.05819f
C24 a_151400_1341400# a_151400_1329400# 0.00328f
C25 a_1043543_981400# a_1047143_987400# 0.05819f
C26 a_1012143_1275400# a_155000_1275400# 0.05819f
C27 a_192600_227200# VDD 2.75151f
C28 a_151400_921400# a_151400_909400# 0
C29 a_1043543_921400# a_1047143_921400# 0.05819f
C30 a_151400_1209400# a_155000_1215400# 0.05819f
C31 a_151400_1149400# a_155000_1149400# 0.05819f
C32 a_1012143_795400# a_155000_795400# 0.05819f
C33 a_1047143_969400# a_1904286_963400# 0.05819f
C34 a_1904286_1263400# a_1904286_1251400# 0
C35 a_155000_1197400# a_1012143_1191400# 0.05819f
C36 a_1043543_1137400# a_1043543_1125400# 0
C37 a_1904286_783400# a_1904286_771400# 0
C38 a_229000_71400# VBP 0.28651f
C39 a_1012143_1011400# a_1012143_999400# 0
C40 a_1904286_1011400# a_1047143_1011400# 0.05819f
C41 a_1043543_945400# a_1047143_951400# 0.05819f
C42 a_1012143_1239400# a_155000_1239400# 0.05819f
C43 a_151400_885400# a_151400_873400# 0
C44 a_1043543_885400# a_1047143_885400# 0.05819f
C45 a_151400_1173400# a_155000_1179400# 0.05819f
C46 a_264600_458100# VSS 2.29723f
C47 a_151400_1113400# a_155000_1113400# 0.05819f
C48 a_1012143_759400# a_155000_759400# 0.05819f
C49 a_156200_71400# VBN 0.57302f
C50 a_1047143_933400# a_1904286_927400# 0.05819f
C51 a_1904286_1227400# a_1904286_1215400# 0
C52 a_155000_1161400# a_1012143_1155400# 0.05819f
C53 a_1043543_1101400# a_1043543_1089400# 0
C54 a_153000_515500# VCM 0.57302f
C55 a_151400_747400# a_264600_458100# 0.28651f
C56 a_229000_363000# a_153000_515500# 2.83362f
C57 a_151400_1329400# a_151400_1317400# 0
C58 a_1043543_1329400# a_1047143_1329400# 0.05819f
C59 a_1012143_975400# a_1012143_963400# 0
C60 a_1904286_975400# a_1047143_975400# 0.05819f
C61 a_1043543_909400# a_1047143_915400# 0.05819f
C62 a_1012143_1203400# a_155000_1203400# 0.05819f
C63 a_151400_849400# a_151400_837400# 0
C64 a_1043543_849400# a_1047143_849400# 0.05819f
C65 a_151400_1137400# a_155000_1143400# 0.05819f
C66 IREF INP 0.28651f
C67 a_151400_1077400# a_155000_1077400# 0.05819f
C68 VSS VBN 1.71906f
C69 VDD INN 0.28651f
C70 a_229000_363000# VBP 0.32256f
C71 a_1047143_897400# a_1904286_891400# 0.05819f
C72 a_1904286_1191400# a_1904286_1179400# 0
C73 a_155000_1125400# a_1012143_1119400# 0.05819f
C74 a_1043543_1065400# a_1043543_1053400# 0
C75 OUTM OUTP 6.20827f
C76 a_151400_1293400# a_151400_1281400# 0
C77 a_1043543_1293400# a_1047143_1293400# 0.05819f
C78 a_1012143_939400# a_1012143_927400# 0
C79 a_1904286_939400# a_1047143_939400# 0.05819f
C80 a_1043543_873400# a_1047143_879400# 0.05819f
C81 a_1012143_1167400# a_155000_1167400# 0.05819f
C82 a_151400_813400# a_151400_801400# 0
C83 a_1043543_813400# a_1047143_813400# 0.05819f
C84 a_151400_1101400# a_155000_1107400# 0.05819f
C85 a_151400_1041400# a_155000_1041400# 0.05819f
C86 a_151400_1341400# a_1043543_1329400# 0.00328f
C87 a_1047143_1341400# a_1904286_1335400# 0.05819f
C88 a_192600_71400# VDD 0.28651f
C89 a_1047143_861400# a_1904286_855400# 0.05819f
C90 a_1904286_1155400# a_1904286_1143400# 0
C91 a_148500_227200# a_192600_227200# 0.28651f
C92 a_155000_1089400# a_1012143_1083400# 0.05819f
C93 a_1043543_1029400# a_1043543_1017400# 0
C94 a_1043543_1317400# a_1047143_1323400# 0.05819f
C95 a_151400_1257400# a_151400_1245400# 0
C96 a_1043543_1257400# a_1047143_1257400# 0.05819f
C97 a_1012143_903400# a_1012143_891400# 0
C98 a_1904286_903400# a_1047143_903400# 0.05819f
C99 a_192600_227200# IREF 1.1821f
C100 a_1043543_837400# a_1047143_843400# 0.05819f
C101 a_1012143_1131400# a_155000_1131400# 0.05819f
C102 a_1043543_777400# a_1047143_777400# 0.05819f
C103 a_151400_777400# a_151400_765400# 0
C104 a_151400_1065400# a_155000_1071400# 0.05819f
C105 a_151400_1005400# a_155000_1005400# 0.05819f
C106 a_1047143_1305400# a_1904286_1299400# 0.05819f
C107 a_148500_363000# VSS 1.09984f
C108 a_1047143_825400# a_1904286_819400# 0.05819f
C109 a_1904286_1119400# a_1904286_1107400# 0
C110 a_155000_1053400# a_1012143_1047400# 0.05819f
C111 a_229000_71400# VBN 0.91104f
C112 a_1043543_993400# a_1043543_981400# 0
C113 a_1043543_1281400# a_1047143_1287400# 0.05819f
C114 a_1012143_867400# a_1012143_855400# 0
C115 a_1904286_867400# a_1047143_867400# 0.05819f
C116 a_151400_1221400# a_151400_1209400# 0
C117 a_1043543_1221400# a_1047143_1221400# 0.05819f
C118 a_1043543_801400# a_1047143_807400# 0.05819f
C119 a_264600_458100# VCM 0.28651f
C120 a_1012143_1095400# a_155000_1095400# 0.05819f
C121 a_151400_747400# a_148500_363000# 0.28783f
C122 a_229000_363000# a_264600_458100# 0.28651f
C123 a_151400_1029400# a_155000_1035400# 0.05819f
C124 a_151400_1341400# OUTM 0.93164f
C125 a_151400_969400# a_155000_969400# 0.05819f
C126 a_1047143_1269400# a_1904286_1263400# 0.05819f
C127 a_156200_71400# INP 0.47348f
C128 a_1047143_789400# a_1904286_783400# 0.05819f
C129 a_1904286_1083400# a_1904286_1071400# 0
C130 a_153000_515500# VBP 0.28651f
C131 a_155000_1017400# a_1012143_1011400# 0.05819f
C132 a_1012143_1311400# a_1012143_1299400# 0
C133 a_1904286_1311400# a_1047143_1311400# 0.05819f
C134 a_1043543_957400# a_1043543_945400# 0
C135 a_1043543_1245400# a_1047143_1251400# 0.05819f
C136 a_1012143_831400# a_1012143_819400# 0
C137 a_1904286_831400# a_1047143_831400# 0.05819f
C138 a_151400_1185400# a_151400_1173400# 0
C139 a_1043543_1185400# a_1047143_1185400# 0.05819f
C140 a_1043543_765400# a_1047143_771400# 0.05819f
C141 a_1012143_1059400# a_155000_1059400# 0.05819f
C142 VSS INP 0.28651f
C143 IREF INN 0.28651f
C144 a_151400_993400# a_155000_999400# 0.05819f
C145 a_151400_933400# a_155000_933400# 0.05819f
C146 a_1047143_1233400# a_1904286_1227400# 0.05819f
C147 a_1047143_753400# a_1904286_747400# 0.05819f
C148 a_1904286_1047400# a_1904286_1035400# 0
C149 a_155000_981400# a_1012143_975400# 0.05819f
C150 a_1012143_1275400# a_1012143_1263400# 0
C151 a_1904286_1275400# a_1047143_1275400# 0.05819f
C152 OUTM VDD 1.26952f
C153 a_1043543_921400# a_1043543_909400# 0
C154 a_1043543_1209400# a_1047143_1215400# 0.05819f
C155 a_1904286_795400# a_1047143_795400# 0.05819f
C156 a_1012143_795400# a_1012143_783400# 0
C157 a_151400_1149400# a_151400_1137400# 0
C158 a_1043543_1149400# a_1047143_1149400# 0.05819f
C159 a_192600_227200# a_156200_71400# 0.9677f
C160 a_1012143_1023400# a_155000_1023400# 0.05819f
C161 a_151400_957400# a_155000_963400# 0.05819f
C162 a_151400_897400# a_155000_897400# 0.05819f
C163 a_192600_71400# IREF 0.28651f
C164 a_1047143_1197400# a_1904286_1191400# 0.05819f
C165 a_1904286_1011400# a_1904286_999400# 0
C166 a_153000_458100# OUTP 0.00152f
C167 a_155000_945400# a_1012143_939400# 0.05819f
C168 a_1012143_1239400# a_1012143_1227400# 0
C169 a_1904286_1239400# a_1047143_1239400# 0.05819f
C170 a_1043543_885400# a_1043543_873400# 0
C171 a_1043543_1173400# a_1047143_1179400# 0.05819f
C172 a_192600_227200# VSS 3.36794f
C173 a_1904286_759400# a_1047143_759400# 0.05819f
C174 a_1012143_759400# a_1012143_747400# 0
C175 a_151400_1113400# a_151400_1101400# 0
C176 a_1043543_1113400# a_1047143_1113400# 0.05819f
C177 a_1012143_987400# a_155000_987400# 0.05819f
C178 a_151400_921400# a_155000_927400# 0.05819f
C179 a_151400_861400# a_155000_861400# 0.05819f
C180 a_1047143_1161400# a_1904286_1155400# 0.05819f
C181 a_148500_363000# VCM 0.65934f
C182 a_229000_363000# a_148500_363000# 0.31018f
C183 a_151400_747400# a_192600_227200# 0.28651f
C184 a_153000_515500# a_264600_458100# 1.34064f
C185 a_1043543_1329400# a_1043543_1317400# 0
C186 a_1904286_975400# a_1904286_963400# 0
C187 a_229000_71400# INP 0.28651f
C188 a_155000_909400# a_1012143_903400# 0.05819f
C189 a_1012143_1203400# a_1012143_1191400# 0
C190 a_1904286_1203400# a_1047143_1203400# 0.05819f
C191 a_1043543_849400# a_1043543_837400# 0
C192 a_1043543_1137400# a_1047143_1143400# 0.05819f
C193 a_151400_1077400# a_151400_1065400# 0
C194 a_1043543_1077400# a_1047143_1077400# 0.05819f
C195 a_151400_1305400# a_155000_1305400# 0.05819f
C196 a_1012143_951400# a_155000_951400# 0.05819f
C197 a_151400_1341400# OUTP 0.64513f
C198 a_151400_885400# a_155000_891400# 0.05819f
C199 a_156200_71400# INN 0.47348f
C200 a_151400_825400# a_155000_825400# 0.05819f
C201 a_1047143_1125400# a_1904286_1119400# 0.05819f
C202 a_1043543_1293400# a_1043543_1281400# 0
C203 a_1904286_939400# a_1904286_927400# 0
C204 a_155000_873400# a_1012143_867400# 0.05819f
C205 a_1012143_1167400# a_1012143_1155400# 0
C206 a_1904286_1167400# a_1047143_1167400# 0.05819f
C207 a_1043543_813400# a_1043543_801400# 0
C208 a_1043543_1101400# a_1047143_1107400# 0.05819f
C209 a_151400_1341400# a_153000_458100# 1.14736f
C210 a_151400_1041400# a_151400_1029400# 0
C211 a_1043543_1041400# a_1047143_1041400# 0.05819f
C212 a_151400_1329400# a_155000_1335400# 0.05819f
C213 VSS INN 0.28651f
C214 VBP VBN 0.57302f
C215 a_151400_1269400# a_155000_1269400# 0.05819f
C216 a_1012143_915400# a_155000_915400# 0.05819f
C217 a_151400_849400# a_155000_855400# 0.05819f
C218 a_151400_789400# a_155000_789400# 0.05819f
C219 a_1047143_1089400# a_1904286_1083400# 0.05819f
C220 a_192600_227200# a_229000_71400# 0.64513f
C221 a_156200_71400# a_192600_71400# 0.92537f
C222 a_148500_227200# OUTM 0.28651f
C223 a_155000_1317400# a_1012143_1311400# 0.05819f
C224 a_1043543_1257400# a_1043543_1245400# 0
C225 a_1904286_903400# a_1904286_891400# 0
C226 OUTP VDD 4.095f
C227 OUTM IREF 1.14604f
C228 a_155000_837400# a_1012143_831400# 0.05819f
C229 a_1012143_1131400# a_1012143_1119400# 0
C230 a_1904286_1131400# a_1047143_1131400# 0.05819f
C231 a_1043543_777400# a_1043543_765400# 0
C232 a_1043543_1065400# a_1047143_1071400# 0.05819f
C233 a_151400_1005400# a_151400_993400# 0
C234 a_1043543_1005400# a_1047143_1005400# 0.05819f
C235 a_151400_1293400# a_155000_1299400# 0.05819f
C236 a_151400_1233400# a_155000_1233400# 0.05819f
C237 a_1012143_879400# a_155000_879400# 0.05819f
C238 a_192600_71400# VSS 1.72421f
C239 a_151400_813400# a_155000_819400# 0.05819f
C240 a_151400_753400# a_155000_753400# 0.05819f
C241 a_1047143_1053400# a_1904286_1047400# 0.05819f
C242 a_153000_458100# VDD 6.69543f
C243 a_155000_1281400# a_1012143_1275400# 0.05819f
C244 a_1904286_867400# a_1904286_855400# 0
C245 a_1043543_1221400# a_1043543_1209400# 0
C246 a_155000_801400# a_1012143_795400# 0.05819f
C247 a_1012143_1095400# a_1012143_1083400# 0
C248 a_1904286_1095400# a_1047143_1095400# 0.05819f
C249 a_229000_363000# a_192600_227200# 0.32256f
C250 a_153000_458100# a_230600_459600# 2.2219f
C251 a_153000_515500# a_148500_363000# 0.3592f
C252 a_1043543_1029400# a_1047143_1035400# 0.05819f
C253 a_1012143_1323400# a_155000_1323400# 0.05819f
C254 a_151400_969400# a_151400_957400# 0
C255 a_1043543_969400# a_1047143_969400# 0.05819f
C256 a_151400_1257400# a_155000_1263400# 0.05819f
C257 a_1012143_843400# a_155000_843400# 0.05819f
C258 a_151400_1197400# a_155000_1197400# 0.05819f
C259 a_151400_777400# a_155000_783400# 0.05819f
C260 a_1047143_1017400# a_1904286_1011400# 0.05819f
C261 a_1904286_1311400# a_1904286_1299400# 0
C262 a_155000_1245400# a_1012143_1239400# 0.05819f
C263 a_229000_71400# INN 0.418f
C264 a_1904286_831400# a_1904286_819400# 0
C265 a_1043543_1185400# a_1043543_1173400# 0
C266 a_155000_765400# a_1012143_759400# 0.05819f
C267 a_1012143_1059400# a_1012143_1047400# 0
C268 a_1904286_1059400# a_1047143_1059400# 0.05819f
C269 a_1043543_993400# a_1047143_999400# 0.05819f
C270 a_1012143_1287400# a_155000_1287400# 0.05819f
C271 a_151400_933400# a_151400_921400# 0
C272 a_1043543_933400# a_1047143_933400# 0.05819f
C273 a_151400_1341400# VDD 2.61465f
C274 a_151400_1221400# a_155000_1227400# 0.05819f
C275 a_1012143_807400# a_155000_807400# 0.05819f
C276 a_151400_1161400# a_155000_1161400# 0.05819f
C277 a_151400_747400# a_155000_747400# 0.05572f
C278 a_151400_1341400# a_230600_459600# 0.51625f
C279 a_1047143_981400# a_1904286_975400# 0.05819f
C280 a_1904286_1275400# a_1904286_1263400# 0
C281 a_155000_1209400# a_1012143_1203400# 0.05819f
C282 a_1904286_795400# a_1904286_783400# 0
C283 a_1043543_1149400# a_1043543_1137400# 0
C284 a_156200_71400# OUTM 0.57302f
C285 a_192600_71400# a_229000_71400# 0.57302f
C286 a_1012143_1023400# a_1012143_1011400# 0
C287 a_1904286_1023400# a_1047143_1023400# 0.05819f
C288 a_1043543_957400# a_1047143_963400# 0.05819f
C289 a_1012143_1251400# a_155000_1251400# 0.05819f
C290 a_151400_897400# a_151400_885400# 0
C291 a_1043543_897400# a_1047143_897400# 0.05819f
C292 VBP INP 0.28651f
C293 a_151400_1185400# a_155000_1191400# 0.05819f
C294 a_1012143_771400# a_155000_771400# 0.05819f
C295 a_151400_1125400# a_155000_1125400# 0.05819f
C296 a_148500_227200# OUTP 0.83366f
C297 a_1047143_945400# a_1904286_939400# 0.05819f
C298 a_1904286_1239400# a_1904286_1227400# 0
C299 a_155000_1173400# a_1012143_1167400# 0.05819f
C300 OUTP IREF 1.18361f
C301 OUTM VSS 1.42198f
C302 a_1043543_1113400# a_1043543_1101400# 0
C303 a_1904286_759400# a_1904286_747400# 0
C304 a_1012143_987400# a_1012143_975400# 0
C305 a_1904286_987400# a_1047143_987400# 0.05819f
C306 a_230600_459600# VDD 5.48361f
C307 a_1043543_921400# a_1047143_927400# 0.05819f
C308 a_1012143_1215400# a_155000_1215400# 0.05819f
C309 a_151400_861400# a_151400_849400# 0
C310 a_1043543_861400# a_1047143_861400# 0.05819f
C311 a_151400_1149400# a_155000_1155400# 0.05819f
C312 a_153000_515500# a_192600_227200# 0.65988f
C313 a_151400_1089400# a_155000_1089400# 0.05819f
C314 a_151400_747400# OUTM 1.21815f
C315 a_264600_458100# a_148500_363000# 0.85953f
C316 a_1047143_909400# a_1904286_903400# 0.05819f
C317 a_153000_458100# IREF 0.96474f
C318 a_1904286_1203400# a_1904286_1191400# 0
C319 a_155000_1137400# a_1012143_1131400# 0.05819f
C320 a_1043543_1077400# a_1043543_1065400# 0
C321 a_192600_227200# VBP 1.53205f
C322 a_151400_1305400# a_151400_1293400# 0
C323 a_1043543_1305400# a_1047143_1305400# 0.05819f
C324 a_1012143_951400# a_1012143_939400# 0
C325 a_1904286_951400# a_1047143_951400# 0.05819f
C326 a_1043543_885400# a_1047143_891400# 0.05819f
C327 a_1012143_1179400# a_155000_1179400# 0.05819f
C328 a_151400_825400# a_151400_813400# 0
C329 a_1043543_825400# a_1047143_825400# 0.05819f
C330 a_151400_1113400# a_155000_1119400# 0.05819f
C331 a_151400_1053400# a_155000_1053400# 0.05819f
C332 a_1047143_873400# a_1904286_867400# 0.05819f
C333 a_1904286_1167400# a_1904286_1155400# 0
C334 a_155000_1101400# a_1012143_1095400# 0.05819f
C335 a_1043543_1041400# a_1043543_1029400# 0
C336 a_1043543_1329400# a_1047143_1335400# 0.05819f
C337 a_151400_1269400# a_151400_1257400# 0
C338 a_1043543_1269400# a_1047143_1269400# 0.05819f
C339 a_1012143_915400# a_1012143_903400# 0
C340 a_1904286_915400# a_1047143_915400# 0.05819f
C341 a_151400_1341400# IREF 0.28651f
C342 a_1043543_849400# a_1047143_855400# 0.05819f
C343 a_1012143_1143400# a_155000_1143400# 0.05819f
C344 a_1043543_789400# a_1047143_789400# 0.05819f
C345 a_151400_789400# a_151400_777400# 0
C346 a_151400_1077400# a_155000_1083400# 0.05819f
C347 a_229000_71400# OUTM 0.57302f
C348 a_151400_1017400# a_155000_1017400# 0.05819f
C349 a_1047143_1317400# a_1904286_1311400# 0.05819f
C350 a_1047143_837400# a_1904286_831400# 0.05819f
C351 a_1904286_1131400# a_1904286_1119400# 0
C352 a_155000_1065400# a_1012143_1059400# 0.05819f
C353 a_156200_71400# OUTP 0.28651f
C354 a_1043543_1005400# a_1043543_993400# 0
C355 a_1043543_1293400# a_1047143_1299400# 0.05819f
C356 a_151400_1233400# a_151400_1221400# 0
C357 a_1043543_1233400# a_1047143_1233400# 0.05819f
C358 a_1012143_879400# a_1012143_867400# 0
C359 a_1904286_879400# a_1047143_879400# 0.05819f
C360 VBN INP 0.28651f
C361 a_1043543_813400# a_1047143_819400# 0.05819f
C362 VBP INN 0.28651f
C363 a_1012143_1107400# a_155000_1107400# 0.05819f
C364 a_1043543_753400# a_1047143_753400# 0.05819f
C365 a_151400_753400# a_151400_747400# 0.00328f
C366 a_151400_1041400# a_155000_1047400# 0.05819f
C367 a_151400_981400# a_155000_981400# 0.05819f
C368 a_148500_227200# VDD 2.14243f
C369 a_1047143_1281400# a_1904286_1275400# 0.05819f
C370 a_1047143_801400# a_1904286_795400# 0.05819f
C371 a_1904286_1095400# a_1904286_1083400# 0
C372 OUTP VSS 1.45275f
C373 VDD IREF 5.80627f
C374 a_229000_363000# OUTM 1.62704f
C375 a_155000_1029400# a_1012143_1023400# 0.05819f
C376 a_1012143_1323400# a_1012143_1311400# 0
C377 a_1904286_1323400# a_1047143_1323400# 0.05819f
C378 a_1043543_969400# a_1043543_957400# 0
C379 a_1043543_1257400# a_1047143_1263400# 0.05819f
C380 a_230600_459600# IREF 1.03686f
C381 a_151400_1197400# a_151400_1185400# 0
C382 a_1043543_1197400# a_1047143_1197400# 0.05819f
C383 a_1012143_843400# a_1012143_831400# 0
C384 a_1904286_843400# a_1047143_843400# 0.05819f
C385 a_1043543_777400# a_1047143_783400# 0.05819f
C386 a_1012143_1071400# a_155000_1071400# 0.05819f
C387 a_192600_71400# VBP 0.28783f
C388 a_151400_1005400# a_155000_1011400# 0.05819f
C389 a_151400_747400# OUTP 1.59098f
C390 a_151400_945400# a_155000_945400# 0.05819f
C391 a_1047143_1245400# a_1904286_1239400# 0.05819f
C392 a_153000_458100# VSS 2.33067f
C393 a_1047143_765400# a_1904286_759400# 0.05819f
C394 a_1904286_1059400# a_1904286_1047400# 0
C395 a_155000_993400# a_1012143_987400# 0.05819f
C396 a_192600_227200# VBN 0.64513f
C397 a_1012143_1287400# a_1012143_1275400# 0
C398 a_1904286_1287400# a_1047143_1287400# 0.05819f
C399 a_1043543_933400# a_1043543_921400# 0
C400 a_1043543_1221400# a_1047143_1227400# 0.05819f
C401 a_151400_1161400# a_151400_1149400# 0
C402 a_1043543_1161400# a_1047143_1161400# 0.05819f
C403 a_1904286_807400# a_1047143_807400# 0.05819f
C404 a_1012143_807400# a_1012143_795400# 0
C405 a_151400_747400# a_153000_458100# 0.65988f
C406 a_229000_363000# a_1047143_747400# 0.05572f
C407 a_1012143_1035400# a_155000_1035400# 0.05819f
C408 a_151400_969400# a_155000_975400# 0.05819f
C409 a_151400_909400# a_155000_909400# 0.05819f
C410 a_1047143_1209400# a_1904286_1203400# 0.05819f
C411 a_1904286_1023400# a_1904286_1011400# 0
C412 a_155000_957400# a_1012143_951400# 0.05819f
C413 a_1012143_1251400# a_1012143_1239400# 0
C414 a_1904286_1251400# a_1047143_1251400# 0.05819f
C415 a_1043543_897400# a_1043543_885400# 0
C416 a_1043543_1185400# a_1047143_1191400# 0.05819f
C417 a_151400_1125400# a_151400_1113400# 0
C418 a_1043543_1125400# a_1047143_1125400# 0.05819f
C419 a_151400_1341400# VSS 1.14604f
C420 a_1904286_771400# a_1047143_771400# 0.05819f
C421 a_1012143_771400# a_1012143_759400# 0
C422 a_1012143_999400# a_155000_999400# 0.05819f
C423 a_229000_71400# OUTP 0.41728f
C424 a_151400_933400# a_155000_939400# 0.05819f
C425 a_151400_873400# a_155000_873400# 0.05819f
C426 a_1047143_1173400# a_1904286_1167400# 0.05819f
C427 a_151400_1341400# a_151400_747400# 0.62483f
C428 a_1904286_987400# a_1904286_975400# 0
C429 a_156200_71400# VDD 0.28651f
C430 a_155000_921400# a_1012143_915400# 0.05819f
C431 a_1043543_861400# a_1043543_849400# 0
C432 a_1012143_1215400# a_1012143_1203400# 0
C433 a_1904286_1215400# a_1047143_1215400# 0.05819f
C434 a_1043543_1149400# a_1047143_1155400# 0.05819f
C435 a_151400_1089400# a_151400_1077400# 0
C436 a_1043543_1089400# a_1047143_1089400# 0.05819f
C437 VBN INN 0.28651f
C438 a_153000_515500# OUTM 13.3921f
C439 a_151400_1317400# a_155000_1317400# 0.05819f
C440 a_1012143_963400# a_155000_963400# 0.05819f
C441 a_151400_897400# a_155000_903400# 0.05819f
C442 a_148500_227200# IREF 0.57302f
C443 a_151400_837400# a_155000_837400# 0.05819f
C444 a_1047143_1137400# a_1904286_1131400# 0.05819f
C445 VDD VSS 7.91799f
C446 OUTM VBP 1.63035f
C447 a_229000_363000# OUTP 1.29026f
C448 a_1043543_1305400# a_1043543_1293400# 0
C449 a_1904286_951400# a_1904286_939400# 0
C450 a_155000_885400# a_1012143_879400# 0.05819f
C451 a_1043543_825400# a_1043543_813400# 0
C452 a_1012143_1179400# a_1012143_1167400# 0
C453 a_1904286_1179400# a_1047143_1179400# 0.05819f
C454 a_230600_459600# VSS 2.58305f
C455 a_1043543_1113400# a_1047143_1119400# 0.05819f
C456 a_151400_1053400# a_151400_1041400# 0
C457 a_1043543_1053400# a_1047143_1053400# 0.05819f
C458 a_192600_71400# VBN 0.91104f
C459 a_151400_747400# VDD 5.07964f
C460 a_151400_1281400# a_155000_1281400# 0.05819f
C461 a_1012143_927400# a_155000_927400# 0.05819f
C462 a_151400_861400# a_155000_867400# 0.05819f
C463 a_151400_801400# a_155000_801400# 0.05819f
C464 a_1047143_1101400# a_1904286_1095400# 0.05819f
C465 a_153000_458100# VCM 0.28651f
C466 a_151400_747400# a_230600_459600# 0.32256f
C467 a_229000_363000# a_153000_458100# 0.66252f
C468 a_155000_1329400# a_1012143_1323400# 0.05819f
C469 a_1043543_1269400# a_1043543_1257400# 0
C470 a_192600_227200# INP 0.32256f
C471 a_1904286_915400# a_1904286_903400# 0
C472 a_155000_849400# a_1012143_843400# 0.05819f
C473 a_1043543_789400# a_1043543_777400# 0
C474 a_1012143_1143400# a_1012143_1131400# 0
C475 a_1904286_1143400# a_1047143_1143400# 0.05819f
C476 a_1043543_1077400# a_1047143_1083400# 0.05819f
C477 a_151400_1017400# a_151400_1005400# 0
C478 a_1043543_1017400# a_1047143_1017400# 0.05819f
C479 a_151400_1305400# a_155000_1311400# 0.05819f
C480 a_151400_1245400# a_155000_1245400# 0.05819f
C481 a_1012143_891400# a_155000_891400# 0.05819f
C482 a_151400_825400# a_155000_831400# 0.05819f
C483 a_151400_765400# a_155000_765400# 0.05819f
C484 a_1047143_1065400# a_1904286_1059400# 0.05819f
C485 a_155000_1293400# a_1012143_1287400# 0.05819f
C486 a_1043543_1233400# a_1043543_1221400# 0
C487 a_1904286_879400# a_1904286_867400# 0
C488 a_155000_813400# a_1012143_807400# 0.05819f
C489 a_1043543_753400# a_229000_363000# 0.00328f
C490 a_1012143_1107400# a_1012143_1095400# 0
C491 a_1904286_1107400# a_1047143_1107400# 0.05819f
C492 a_151400_1341400# VCM 0.28651f
C493 a_151400_1341400# a_229000_363000# 0.62483f
C494 a_1043543_1041400# a_1047143_1047400# 0.05819f
C495 a_1012143_1335400# a_155000_1335400# 0.05819f
C496 a_151400_981400# a_151400_969400# 0
C497 a_1043543_981400# a_1047143_981400# 0.05819f
C498 a_229000_71400# VDD 0.28651f
C499 a_151400_1269400# a_155000_1275400# 0.05819f
C500 a_151400_1209400# a_155000_1209400# 0.05819f
C501 a_1012143_855400# a_155000_855400# 0.05819f
C502 a_151400_789400# a_155000_795400# 0.05819f
C503 a_1047143_1029400# a_1904286_1023400# 0.05819f
C504 a_1904286_1323400# a_1904286_1311400# 0
C505 a_155000_1257400# a_1012143_1251400# 0.05819f
C506 a_156200_71400# IREF 1.03977f
C507 a_1043543_1197400# a_1043543_1185400# 0
C508 a_1904286_843400# a_1904286_831400# 0
C509 a_155000_777400# a_1012143_771400# 0.05819f
C510 INP INN 0.28651f
C511 a_1012143_1071400# a_1012143_1059400# 0
C512 a_1904286_1071400# a_1047143_1071400# 0.05819f
C513 a_1043543_1005400# a_1047143_1011400# 0.05819f
C514 a_153000_515500# OUTP 13.3931f
C515 a_1012143_1299400# a_155000_1299400# 0.05819f
C516 a_151400_945400# a_151400_933400# 0
C517 a_1043543_945400# a_1047143_945400# 0.05819f
C518 a_151400_1233400# a_155000_1239400# 0.05819f
C519 a_151400_1173400# a_155000_1173400# 0.05819f
C520 a_148500_227200# VSS 1.14604f
C521 a_1012143_819400# a_155000_819400# 0.05819f
C522 a_151400_753400# a_155000_759400# 0.05819f
C523 a_1047143_993400# a_1904286_987400# 0.05819f
C524 OUTP VBP 1.6664f
C525 OUTM VBN 0.82212f
C526 IREF VSS 6.54819f
C527 VDD VCM 2.00633f
C528 a_229000_363000# VDD 5.33203f
C529 a_1904286_1287400# a_1904286_1275400# 0
C530 a_155000_1221400# a_1012143_1215400# 0.05819f
C531 a_1043543_1161400# a_1043543_1149400# 0
C532 a_1904286_807400# a_1904286_795400# 0
C533 a_230600_459600# VCM 0.32256f
C534 a_151400_747400# a_148500_227200# 0.57302f
C535 a_229000_363000# a_230600_459600# 0.32256f
C536 a_153000_515500# a_153000_458100# 1.14604f
C537 a_1012143_1035400# a_1012143_1023400# 0
C538 a_1904286_1035400# a_1047143_1035400# 0.05819f
C539 a_1043543_969400# a_1047143_975400# 0.05819f
C540 a_1012143_1263400# a_155000_1263400# 0.05819f
C541 a_151400_909400# a_151400_897400# 0
C542 a_1043543_909400# a_1047143_909400# 0.05819f
C543 a_192600_71400# INP 0.418f
C544 a_151400_747400# IREF 0.85953f
C545 a_151400_1197400# a_155000_1203400# 0.05819f
C546 a_151400_1137400# a_155000_1137400# 0.05819f
C547 a_1012143_783400# a_155000_783400# 0.05819f
C548 a_1047143_957400# a_1904286_951400# 0.05819f
C549 a_1904286_1251400# a_1904286_1239400# 0
C550 a_192600_227200# INN 0.32256f
C551 a_155000_1185400# a_1012143_1179400# 0.05819f
C552 a_1043543_1125400# a_1043543_1113400# 0
C553 a_1904286_771400# a_1904286_759400# 0
C554 a_1012143_999400# a_1012143_987400# 0
C555 a_1904286_999400# a_1047143_999400# 0.05819f
C556 a_1043543_933400# a_1047143_939400# 0.05819f
C557 a_1012143_1227400# a_155000_1227400# 0.05819f
C558 a_151400_873400# a_151400_861400# 0
C559 a_1043543_873400# a_1047143_873400# 0.05819f
C560 a_151400_1161400# a_155000_1167400# 0.05819f
C561 a_151400_1101400# a_155000_1101400# 0.05819f
C562 a_1012143_747400# a_155000_747400# 0.05819f
C563 a_151400_1341400# a_153000_515500# 1.86328f
C564 a_1047143_921400# a_1904286_915400# 0.05819f
C565 a_1904286_1215400# a_1904286_1203400# 0
C566 a_155000_1149400# a_1012143_1143400# 0.05819f
C567 a_1043543_1089400# a_1043543_1077400# 0
C568 a_192600_227200# a_192600_71400# 0.64513f
C569 a_151400_1317400# a_151400_1305400# 0
C570 a_1043543_1317400# a_1047143_1317400# 0.05819f
C571 a_1012143_963400# a_1012143_951400# 0
C572 a_1904286_963400# a_1047143_963400# 0.05819f
C573 a_1043543_897400# a_1047143_903400# 0.05819f
C574 a_229000_71400# IREF 0.28651f
C575 a_151400_837400# a_151400_825400# 0
C576 a_1043543_837400# a_1047143_837400# 0.05819f
C577 a_1012143_1191400# a_155000_1191400# 0.05819f
C578 a_151400_1125400# a_155000_1131400# 0.05819f
C579 a_151400_1065400# a_155000_1065400# 0.05819f
C580 a_264600_458100# OUTP 0.00338f
C581 a_1047143_885400# a_1904286_879400# 0.05819f
C582 a_156200_71400# VSS 1.99514f
C583 a_1904286_1179400# a_1904286_1167400# 0
C584 a_155000_1113400# a_1012143_1107400# 0.05819f
C585 a_1043543_1053400# a_1043543_1041400# 0
C586 a_153000_515500# VDD 13.663f
C587 a_151400_1281400# a_151400_1269400# 0
C588 a_1043543_1281400# a_1047143_1281400# 0.05819f
C589 a_1012143_927400# a_1012143_915400# 0
C590 a_1904286_927400# a_1047143_927400# 0.05819f
C591 a_1043543_861400# a_1047143_867400# 0.05819f
C592 a_1043543_801400# a_1047143_801400# 0.05819f
C593 a_151400_801400# a_151400_789400# 0
C594 a_1012143_1155400# a_155000_1155400# 0.05819f
C595 a_151400_1089400# a_155000_1095400# 0.05819f
C596 a_153000_515500# a_230600_459600# 1.28758f
C597 a_153000_458100# a_264600_458100# 2.02924f
C598 a_229000_363000# a_148500_227200# 0.64513f
C599 a_151400_1029400# a_155000_1029400# 0.05819f
C600 a_1047143_1329400# a_1904286_1323400# 0.05819f
C601 OUTP VBN 0.5356f
C602 OUTM INP 0.28651f
C603 IREF VCM 0.02367f
C604 VDD VBP 2.57973f
C605 a_229000_363000# IREF 0.93164f
C606 a_1047143_849400# a_1904286_843400# 0.05819f
C607 a_1904286_1143400# a_1904286_1131400# 0
C608 a_155000_1077400# a_1012143_1071400# 0.05819f
C609 a_1043543_1017400# a_1043543_1005400# 0
C610 a_1043543_1305400# a_1047143_1311400# 0.05819f
C611 a_151400_1245400# a_151400_1233400# 0
C612 a_1043543_1245400# a_1047143_1245400# 0.05819f
C613 a_1012143_891400# a_1012143_879400# 0
C614 a_1904286_891400# a_1047143_891400# 0.05819f
C615 a_192600_71400# INN 0.28651f
C616 a_1043543_825400# a_1047143_831400# 0.05819f
C617 a_151400_747400# VSS 2.8189f
C618 a_1043543_765400# a_1047143_765400# 0.05819f
C619 a_151400_765400# a_151400_753400# 0
C620 a_1012143_1119400# a_155000_1119400# 0.05819f
C621 a_151400_1053400# a_155000_1059400# 0.05819f
C622 a_151400_993400# a_155000_993400# 0.05819f
C623 a_1047143_1293400# a_1904286_1287400# 0.05819f
C624 a_1047143_813400# a_1904286_807400# 0.05819f
C625 a_1904286_1107400# a_1904286_1095400# 0
C626 a_151400_1341400# a_264600_458100# 0.70543f
C627 a_155000_1041400# a_1012143_1035400# 0.05819f
C628 a_1012143_1335400# a_1012143_1323400# 0
C629 a_1904286_1335400# a_1047143_1335400# 0.05819f
C630 a_1043543_981400# a_1043543_969400# 0
C631 a_1043543_1269400# a_1047143_1275400# 0.05819f
C632 a_151400_1209400# a_151400_1197400# 0
C633 a_1043543_1209400# a_1047143_1209400# 0.05819f
C634 a_1012143_855400# a_1012143_843400# 0
C635 a_1904286_855400# a_1047143_855400# 0.05819f
C636 a_1043543_789400# a_1047143_795400# 0.05819f
C637 a_156200_71400# a_229000_71400# 0.92537f
C638 a_192600_227200# OUTM 1.4788f
C639 a_1012143_1083400# a_155000_1083400# 0.05819f
C640 a_151400_1017400# a_155000_1023400# 0.05819f
C641 a_151400_957400# a_155000_957400# 0.05819f
C642 a_1047143_1257400# a_1904286_1251400# 0.05819f
C643 a_1047143_777400# a_1904286_771400# 0.05819f
C644 a_1904286_1071400# a_1904286_1059400# 0
C645 a_155000_1005400# a_1012143_999400# 0.05819f
C646 a_1012143_1299400# a_1012143_1287400# 0
C647 a_1904286_1299400# a_1047143_1299400# 0.05819f
C648 a_1043543_945400# a_1043543_933400# 0
C649 a_1043543_1233400# a_1047143_1239400# 0.05819f
C650 a_151400_1173400# a_151400_1161400# 0
C651 a_1043543_1173400# a_1047143_1173400# 0.05819f
C652 a_229000_71400# VSS 1.72421f
C653 a_1012143_819400# a_1012143_807400# 0
C654 a_1904286_819400# a_1047143_819400# 0.05819f
C655 a_1043543_753400# a_1047143_759400# 0.05819f
C656 a_1012143_1047400# a_155000_1047400# 0.05819f
C657 a_151400_1341400# a_155000_1341400# 0.05572f
C658 a_151400_981400# a_155000_987400# 0.05819f
C659 a_264600_458100# VDD 5.50093f
C660 a_151400_921400# a_155000_921400# 0.05819f
C661 a_1047143_1221400# a_1904286_1215400# 0.05819f
C662 a_153000_458100# a_148500_363000# 1.2329f
C663 a_153000_515500# a_148500_227200# 0.94639f
C664 a_264600_458100# a_230600_459600# 1.61146f
C665 a_1904286_1035400# a_1904286_1023400# 0
C666 a_155000_969400# a_1012143_963400# 0.05819f
C667 a_1012143_1263400# a_1012143_1251400# 0
C668 a_1904286_1263400# a_1047143_1263400# 0.05819f
C669 a_1043543_909400# a_1043543_897400# 0
C670 a_153000_515500# IREF 1.43255f
C671 a_1043543_1197400# a_1047143_1203400# 0.05819f
C672 a_151400_1137400# a_151400_1125400# 0
C673 a_1043543_1137400# a_1047143_1137400# 0.05819f
C674 a_1904286_783400# a_1047143_783400# 0.05819f
C675 a_1012143_783400# a_1012143_771400# 0
C676 a_148500_227200# VBP 0.92297f
C677 a_1012143_1011400# a_155000_1011400# 0.05819f
C678 a_151400_945400# a_155000_951400# 0.05819f
C679 a_151400_885400# a_155000_885400# 0.05819f
C680 VSS VCM 1.12636f
C681 VDD VBN 0.28651f
C682 IREF VBP 1.14604f
C683 OUTP INP 0.28651f
C684 OUTM INN 0.28651f
C685 a_1047143_1185400# a_1904286_1179400# 0.05819f
C686 a_229000_363000# VSS 2.96312f
C687 a_1904286_999400# a_1904286_987400# 0
C688 a_155000_933400# a_1012143_927400# 0.05819f
C689 a_1043543_873400# a_1043543_861400# 0
C690 a_1012143_1227400# a_1012143_1215400# 0
C691 a_1904286_1227400# a_1047143_1227400# 0.05819f
C692 a_1043543_1161400# a_1047143_1167400# 0.05819f
C693 a_151400_1101400# a_151400_1089400# 0
C694 a_1043543_1101400# a_1047143_1101400# 0.05819f
C695 a_151400_747400# VCM 0.57302f
C696 a_1904286_747400# a_1047143_747400# 0.05819f
C697 a_151400_747400# a_229000_363000# 0.96658f
C698 a_151400_1341400# a_148500_363000# 0.85953f
C699 a_151400_1329400# a_155000_1329400# 0.05819f
C700 a_1012143_975400# a_155000_975400# 0.05819f
C701 a_151400_909400# a_155000_915400# 0.05819f
C702 a_151400_849400# a_155000_849400# 0.05819f
C703 a_1047143_1149400# a_1904286_1143400# 0.05819f
C704 a_192600_71400# OUTM 0.70379f
C705 a_1043543_1317400# a_1043543_1305400# 0
C706 a_1904286_963400# a_1904286_951400# 0
C707 a_155000_897400# a_1012143_891400# 0.05819f
C708 a_1043543_837400# a_1043543_825400# 0
C709 a_1012143_1191400# a_1012143_1179400# 0
C710 a_1904286_1191400# a_1047143_1191400# 0.05819f
C711 a_1043543_1125400# a_1047143_1131400# 0.05819f
C712 a_151400_1065400# a_151400_1053400# 0
C713 a_1043543_1065400# a_1047143_1065400# 0.05819f
C714 a_192600_227200# OUTP 1.21815f
C715 a_151400_1293400# a_155000_1293400# 0.05819f
C716 a_1012143_939400# a_155000_939400# 0.05819f
C717 a_151400_873400# a_155000_879400# 0.05819f
C718 a_151400_813400# a_155000_813400# 0.05819f
C719 a_1047143_1113400# a_1904286_1107400# 0.05819f
C720 a_151400_1341400# a_1047143_1341400# 0.05572f
C721 a_155000_1341400# a_1012143_1335400# 0.05819f
C722 a_1043543_1281400# a_1043543_1269400# 0
C723 a_148500_363000# VDD 2.14243f
C724 a_1904286_927400# a_1904286_915400# 0
C725 a_155000_861400# a_1012143_855400# 0.05819f
C726 a_1043543_801400# a_1043543_789400# 0
C727 a_1012143_1155400# a_1012143_1143400# 0
C728 a_1904286_1155400# a_1047143_1155400# 0.05819f
C729 a_230600_459600# a_148500_363000# 1.11405f
C730 a_1043543_1089400# a_1047143_1095400# 0.05819f
C731 a_151400_1029400# a_151400_1017400# 0
C732 a_1043543_1029400# a_1047143_1029400# 0.05819f
C733 a_151400_1317400# a_155000_1323400# 0.05819f
C734 a_151400_1257400# a_155000_1257400# 0.05819f
C735 a_264600_458100# IREF 0.85953f
C736 a_1012143_903400# a_155000_903400# 0.05819f
C737 a_151400_837400# a_155000_843400# 0.05819f
C738 a_151400_777400# a_155000_777400# 0.05819f
C739 a_1047143_1077400# a_1904286_1071400# 0.05819f
C740 a_156200_71400# VBP 0.31018f
C741 a_155000_1305400# a_1012143_1299400# 0.05819f
C742 a_1043543_1245400# a_1043543_1233400# 0
C743 a_1904286_891400# a_1904286_879400# 0
C744 a_155000_825400# a_1012143_819400# 0.05819f
C745 a_153000_515500# VSS 3.72978f
C746 a_1043543_765400# a_1043543_753400# 0
C747 a_1012143_1119400# a_1012143_1107400# 0
C748 a_1904286_1119400# a_1047143_1119400# 0.05819f
C749 a_1043543_1053400# a_1047143_1059400# 0.05819f
C750 a_151400_993400# a_151400_981400# 0
C751 a_1043543_993400# a_1047143_993400# 0.05819f
C752 a_151400_1281400# a_155000_1287400# 0.05819f
C753 a_151400_1221400# a_155000_1221400# 0.05819f
C754 a_1012143_867400# a_155000_867400# 0.05819f
C755 VSS VBP 3.15161f
C756 IREF VBN 0.28783f
C757 OUTP INN 0.28651f
C758 VDD INP 0.28651f
C759 a_151400_801400# a_155000_807400# 0.05819f
C760 a_229000_363000# VCM 0.57302f
C761 a_151400_747400# a_153000_515500# 2.8062f
C762 a_1047143_1041400# a_1904286_1035400# 0.05819f
C763 a_1904286_1335400# a_1904286_1323400# 0
C764 INN 0 40.0032f
C765 INP 0 51.3263f
C766 VBN 0 47.3166f
C767 VBP 0 95.1689f
C768 VCM 0 37.9382f
C769 VSS 0 0.25692p
C770 IREF 0 0.17741p
C771 VDD 0 0.41288p
C772 OUTP 0 0.33846p
C773 OUTM 0 0.3247p
C774 a_229000_71400# 0 24.2488f ; **FLOATING
C775 a_192600_71400# 0 26.0809f ; **FLOATING
C776 a_156200_71400# 0 34.3217f ; **FLOATING
C777 a_192600_227200# 0 71.11021f ; **FLOATING
C778 a_148500_227200# 0 27.9443f ; **FLOATING
C779 a_148500_363000# 0 38.3276f ; **FLOATING
C780 a_230600_459600# 0 60.346f ; **FLOATING
C781 a_264600_458100# 0 69.49829f ; **FLOATING
C782 a_153000_458100# 0 0.1047p ; **FLOATING
C783 a_153000_515500# 0 0.52762p ; **FLOATING
C784 a_1047143_747400# 0 0.26972p ; **FLOATING
C785 a_229000_363000# 0 0.23638p ; **FLOATING
C786 a_155000_747400# 0 0.26972p ; **FLOATING
C787 a_151400_747400# 0 0.11805p ; **FLOATING
C788 a_1904286_747400# 0 3.33625f
C789 a_1047143_753400# 0 0.26583p ; **FLOATING
C790 a_1012143_747400# 0 3.33625f
C791 a_155000_753400# 0 0.26583p ; **FLOATING
C792 a_1047143_759400# 0 0.26583p ; **FLOATING
C793 a_1043543_753400# 0 3.29428f ; **FLOATING
C794 a_155000_759400# 0 0.26583p ; **FLOATING
C795 a_151400_753400# 0 3.29428f ; **FLOATING
C796 a_1904286_759400# 0 3.29428f
C797 a_1047143_765400# 0 0.26583p ; **FLOATING
C798 a_1012143_759400# 0 3.29428f
C799 a_155000_765400# 0 0.26583p ; **FLOATING
C800 a_1047143_771400# 0 0.26583p ; **FLOATING
C801 a_1043543_765400# 0 3.29428f ; **FLOATING
C802 a_155000_771400# 0 0.26583p ; **FLOATING
C803 a_151400_765400# 0 3.29428f ; **FLOATING
C804 a_1904286_771400# 0 3.29428f
C805 a_1047143_777400# 0 0.26583p ; **FLOATING
C806 a_1012143_771400# 0 3.29428f
C807 a_155000_777400# 0 0.26583p ; **FLOATING
C808 a_1047143_783400# 0 0.26583p ; **FLOATING
C809 a_1043543_777400# 0 3.29428f ; **FLOATING
C810 a_155000_783400# 0 0.26583p ; **FLOATING
C811 a_151400_777400# 0 3.29428f ; **FLOATING
C812 a_1904286_783400# 0 3.29428f
C813 a_1047143_789400# 0 0.26583p ; **FLOATING
C814 a_1012143_783400# 0 3.29428f
C815 a_155000_789400# 0 0.26583p ; **FLOATING
C816 a_1047143_795400# 0 0.26583p ; **FLOATING
C817 a_1043543_789400# 0 3.29428f ; **FLOATING
C818 a_155000_795400# 0 0.26583p ; **FLOATING
C819 a_151400_789400# 0 3.29428f ; **FLOATING
C820 a_1904286_795400# 0 3.29428f
C821 a_1047143_801400# 0 0.26583p ; **FLOATING
C822 a_1012143_795400# 0 3.29428f
C823 a_155000_801400# 0 0.26583p ; **FLOATING
C824 a_1047143_807400# 0 0.26583p ; **FLOATING
C825 a_1043543_801400# 0 3.29428f ; **FLOATING
C826 a_155000_807400# 0 0.26583p ; **FLOATING
C827 a_151400_801400# 0 3.29428f ; **FLOATING
C828 a_1904286_807400# 0 3.29428f
C829 a_1047143_813400# 0 0.26583p ; **FLOATING
C830 a_1012143_807400# 0 3.29428f
C831 a_155000_813400# 0 0.26583p ; **FLOATING
C832 a_1047143_819400# 0 0.26583p ; **FLOATING
C833 a_1043543_813400# 0 3.29428f ; **FLOATING
C834 a_155000_819400# 0 0.26583p ; **FLOATING
C835 a_151400_813400# 0 3.29428f ; **FLOATING
C836 a_1904286_819400# 0 3.29428f
C837 a_1047143_825400# 0 0.26583p ; **FLOATING
C838 a_1012143_819400# 0 3.29428f
C839 a_155000_825400# 0 0.26583p ; **FLOATING
C840 a_1047143_831400# 0 0.26583p ; **FLOATING
C841 a_1043543_825400# 0 3.29428f ; **FLOATING
C842 a_155000_831400# 0 0.26583p ; **FLOATING
C843 a_151400_825400# 0 3.29428f ; **FLOATING
C844 a_1904286_831400# 0 3.29428f
C845 a_1047143_837400# 0 0.26583p ; **FLOATING
C846 a_1012143_831400# 0 3.29428f
C847 a_155000_837400# 0 0.26583p ; **FLOATING
C848 a_1047143_843400# 0 0.26583p ; **FLOATING
C849 a_1043543_837400# 0 3.29428f ; **FLOATING
C850 a_155000_843400# 0 0.26583p ; **FLOATING
C851 a_151400_837400# 0 3.29428f ; **FLOATING
C852 a_1904286_843400# 0 3.29428f
C853 a_1047143_849400# 0 0.26583p ; **FLOATING
C854 a_1012143_843400# 0 3.29428f
C855 a_155000_849400# 0 0.26583p ; **FLOATING
C856 a_1047143_855400# 0 0.26583p ; **FLOATING
C857 a_1043543_849400# 0 3.29428f ; **FLOATING
C858 a_155000_855400# 0 0.26583p ; **FLOATING
C859 a_151400_849400# 0 3.29428f ; **FLOATING
C860 a_1904286_855400# 0 3.29428f
C861 a_1047143_861400# 0 0.26583p ; **FLOATING
C862 a_1012143_855400# 0 3.29428f
C863 a_155000_861400# 0 0.26583p ; **FLOATING
C864 a_1047143_867400# 0 0.26583p ; **FLOATING
C865 a_1043543_861400# 0 3.29428f ; **FLOATING
C866 a_155000_867400# 0 0.26583p ; **FLOATING
C867 a_151400_861400# 0 3.29428f ; **FLOATING
C868 a_1904286_867400# 0 3.29428f
C869 a_1047143_873400# 0 0.26583p ; **FLOATING
C870 a_1012143_867400# 0 3.29428f
C871 a_155000_873400# 0 0.26583p ; **FLOATING
C872 a_1047143_879400# 0 0.26583p ; **FLOATING
C873 a_1043543_873400# 0 3.29428f ; **FLOATING
C874 a_155000_879400# 0 0.26583p ; **FLOATING
C875 a_151400_873400# 0 3.29428f ; **FLOATING
C876 a_1904286_879400# 0 3.29428f
C877 a_1047143_885400# 0 0.26583p ; **FLOATING
C878 a_1012143_879400# 0 3.29428f
C879 a_155000_885400# 0 0.26583p ; **FLOATING
C880 a_1047143_891400# 0 0.26583p ; **FLOATING
C881 a_1043543_885400# 0 3.29428f ; **FLOATING
C882 a_155000_891400# 0 0.26583p ; **FLOATING
C883 a_151400_885400# 0 3.29428f ; **FLOATING
C884 a_1904286_891400# 0 3.29428f
C885 a_1047143_897400# 0 0.26583p ; **FLOATING
C886 a_1012143_891400# 0 3.29428f
C887 a_155000_897400# 0 0.26583p ; **FLOATING
C888 a_1047143_903400# 0 0.26583p ; **FLOATING
C889 a_1043543_897400# 0 3.29428f ; **FLOATING
C890 a_155000_903400# 0 0.26583p ; **FLOATING
C891 a_151400_897400# 0 3.29428f ; **FLOATING
C892 a_1904286_903400# 0 3.29428f
C893 a_1047143_909400# 0 0.26583p ; **FLOATING
C894 a_1012143_903400# 0 3.29428f
C895 a_155000_909400# 0 0.26583p ; **FLOATING
C896 a_1047143_915400# 0 0.26583p ; **FLOATING
C897 a_1043543_909400# 0 3.29428f ; **FLOATING
C898 a_155000_915400# 0 0.26583p ; **FLOATING
C899 a_151400_909400# 0 3.29428f ; **FLOATING
C900 a_1904286_915400# 0 3.29428f
C901 a_1047143_921400# 0 0.26583p ; **FLOATING
C902 a_1012143_915400# 0 3.29428f
C903 a_155000_921400# 0 0.26583p ; **FLOATING
C904 a_1047143_927400# 0 0.26583p ; **FLOATING
C905 a_1043543_921400# 0 3.29428f ; **FLOATING
C906 a_155000_927400# 0 0.26583p ; **FLOATING
C907 a_151400_921400# 0 3.29428f ; **FLOATING
C908 a_1904286_927400# 0 3.29428f
C909 a_1047143_933400# 0 0.26583p ; **FLOATING
C910 a_1012143_927400# 0 3.29428f
C911 a_155000_933400# 0 0.26583p ; **FLOATING
C912 a_1047143_939400# 0 0.26583p ; **FLOATING
C913 a_1043543_933400# 0 3.29428f ; **FLOATING
C914 a_155000_939400# 0 0.26583p ; **FLOATING
C915 a_151400_933400# 0 3.29428f ; **FLOATING
C916 a_1904286_939400# 0 3.29428f
C917 a_1047143_945400# 0 0.26583p ; **FLOATING
C918 a_1012143_939400# 0 3.29428f
C919 a_155000_945400# 0 0.26583p ; **FLOATING
C920 a_1047143_951400# 0 0.26583p ; **FLOATING
C921 a_1043543_945400# 0 3.29428f ; **FLOATING
C922 a_155000_951400# 0 0.26583p ; **FLOATING
C923 a_151400_945400# 0 3.29428f ; **FLOATING
C924 a_1904286_951400# 0 3.29428f
C925 a_1047143_957400# 0 0.26583p ; **FLOATING
C926 a_1012143_951400# 0 3.29428f
C927 a_155000_957400# 0 0.26583p ; **FLOATING
C928 a_1047143_963400# 0 0.26583p ; **FLOATING
C929 a_1043543_957400# 0 3.29428f ; **FLOATING
C930 a_155000_963400# 0 0.26583p ; **FLOATING
C931 a_151400_957400# 0 3.29428f ; **FLOATING
C932 a_1904286_963400# 0 3.29428f
C933 a_1047143_969400# 0 0.26583p ; **FLOATING
C934 a_1012143_963400# 0 3.29428f
C935 a_155000_969400# 0 0.26583p ; **FLOATING
C936 a_1047143_975400# 0 0.26583p ; **FLOATING
C937 a_1043543_969400# 0 3.29428f ; **FLOATING
C938 a_155000_975400# 0 0.26583p ; **FLOATING
C939 a_151400_969400# 0 3.29428f ; **FLOATING
C940 a_1904286_975400# 0 3.29428f
C941 a_1047143_981400# 0 0.26583p ; **FLOATING
C942 a_1012143_975400# 0 3.29428f
C943 a_155000_981400# 0 0.26583p ; **FLOATING
C944 a_1047143_987400# 0 0.26583p ; **FLOATING
C945 a_1043543_981400# 0 3.29428f ; **FLOATING
C946 a_155000_987400# 0 0.26583p ; **FLOATING
C947 a_151400_981400# 0 3.29428f ; **FLOATING
C948 a_1904286_987400# 0 3.29428f
C949 a_1047143_993400# 0 0.26583p ; **FLOATING
C950 a_1012143_987400# 0 3.29428f
C951 a_155000_993400# 0 0.26583p ; **FLOATING
C952 a_1047143_999400# 0 0.26583p ; **FLOATING
C953 a_1043543_993400# 0 3.29428f ; **FLOATING
C954 a_155000_999400# 0 0.26583p ; **FLOATING
C955 a_151400_993400# 0 3.29428f ; **FLOATING
C956 a_1904286_999400# 0 3.29428f
C957 a_1047143_1005400# 0 0.26583p ; **FLOATING
C958 a_1012143_999400# 0 3.29428f
C959 a_155000_1005400# 0 0.26583p ; **FLOATING
C960 a_1047143_1011400# 0 0.26583p ; **FLOATING
C961 a_1043543_1005400# 0 3.29428f ; **FLOATING
C962 a_155000_1011400# 0 0.26583p ; **FLOATING
C963 a_151400_1005400# 0 3.29428f ; **FLOATING
C964 a_1904286_1011400# 0 3.29428f
C965 a_1047143_1017400# 0 0.26583p ; **FLOATING
C966 a_1012143_1011400# 0 3.29428f
C967 a_155000_1017400# 0 0.26583p ; **FLOATING
C968 a_1047143_1023400# 0 0.26583p ; **FLOATING
C969 a_1043543_1017400# 0 3.29428f ; **FLOATING
C970 a_155000_1023400# 0 0.26583p ; **FLOATING
C971 a_151400_1017400# 0 3.29428f ; **FLOATING
C972 a_1904286_1023400# 0 3.29428f
C973 a_1047143_1029400# 0 0.26583p ; **FLOATING
C974 a_1012143_1023400# 0 3.29428f
C975 a_155000_1029400# 0 0.26583p ; **FLOATING
C976 a_1047143_1035400# 0 0.26583p ; **FLOATING
C977 a_1043543_1029400# 0 3.29428f ; **FLOATING
C978 a_155000_1035400# 0 0.26583p ; **FLOATING
C979 a_151400_1029400# 0 3.29428f ; **FLOATING
C980 a_1904286_1035400# 0 3.29428f
C981 a_1047143_1041400# 0 0.26583p ; **FLOATING
C982 a_1012143_1035400# 0 3.29428f
C983 a_155000_1041400# 0 0.26583p ; **FLOATING
C984 a_1047143_1047400# 0 0.26583p ; **FLOATING
C985 a_1043543_1041400# 0 3.29428f ; **FLOATING
C986 a_155000_1047400# 0 0.26583p ; **FLOATING
C987 a_151400_1041400# 0 3.29428f ; **FLOATING
C988 a_1904286_1047400# 0 3.29428f
C989 a_1047143_1053400# 0 0.26583p ; **FLOATING
C990 a_1012143_1047400# 0 3.29428f
C991 a_155000_1053400# 0 0.26583p ; **FLOATING
C992 a_1047143_1059400# 0 0.26583p ; **FLOATING
C993 a_1043543_1053400# 0 3.29428f ; **FLOATING
C994 a_155000_1059400# 0 0.26583p ; **FLOATING
C995 a_151400_1053400# 0 3.29428f ; **FLOATING
C996 a_1904286_1059400# 0 3.29428f
C997 a_1047143_1065400# 0 0.26583p ; **FLOATING
C998 a_1012143_1059400# 0 3.29428f
C999 a_155000_1065400# 0 0.26583p ; **FLOATING
C1000 a_1047143_1071400# 0 0.26583p ; **FLOATING
C1001 a_1043543_1065400# 0 3.29428f ; **FLOATING
C1002 a_155000_1071400# 0 0.26583p ; **FLOATING
C1003 a_151400_1065400# 0 3.29428f ; **FLOATING
C1004 a_1904286_1071400# 0 3.29428f
C1005 a_1047143_1077400# 0 0.26583p ; **FLOATING
C1006 a_1012143_1071400# 0 3.29428f
C1007 a_155000_1077400# 0 0.26583p ; **FLOATING
C1008 a_1047143_1083400# 0 0.26583p ; **FLOATING
C1009 a_1043543_1077400# 0 3.29428f ; **FLOATING
C1010 a_155000_1083400# 0 0.26583p ; **FLOATING
C1011 a_151400_1077400# 0 3.29428f ; **FLOATING
C1012 a_1904286_1083400# 0 3.29428f
C1013 a_1047143_1089400# 0 0.26583p ; **FLOATING
C1014 a_1012143_1083400# 0 3.29428f
C1015 a_155000_1089400# 0 0.26583p ; **FLOATING
C1016 a_1047143_1095400# 0 0.26583p ; **FLOATING
C1017 a_1043543_1089400# 0 3.29428f ; **FLOATING
C1018 a_155000_1095400# 0 0.26583p ; **FLOATING
C1019 a_151400_1089400# 0 3.29428f ; **FLOATING
C1020 a_1904286_1095400# 0 3.29428f
C1021 a_1047143_1101400# 0 0.26583p ; **FLOATING
C1022 a_1012143_1095400# 0 3.29428f
C1023 a_155000_1101400# 0 0.26583p ; **FLOATING
C1024 a_1047143_1107400# 0 0.26583p ; **FLOATING
C1025 a_1043543_1101400# 0 3.29428f ; **FLOATING
C1026 a_155000_1107400# 0 0.26583p ; **FLOATING
C1027 a_151400_1101400# 0 3.29428f ; **FLOATING
C1028 a_1904286_1107400# 0 3.29428f
C1029 a_1047143_1113400# 0 0.26583p ; **FLOATING
C1030 a_1012143_1107400# 0 3.29428f
C1031 a_155000_1113400# 0 0.26583p ; **FLOATING
C1032 a_1047143_1119400# 0 0.26583p ; **FLOATING
C1033 a_1043543_1113400# 0 3.29428f ; **FLOATING
C1034 a_155000_1119400# 0 0.26583p ; **FLOATING
C1035 a_151400_1113400# 0 3.29428f ; **FLOATING
C1036 a_1904286_1119400# 0 3.29428f
C1037 a_1047143_1125400# 0 0.26583p ; **FLOATING
C1038 a_1012143_1119400# 0 3.29428f
C1039 a_155000_1125400# 0 0.26583p ; **FLOATING
C1040 a_1047143_1131400# 0 0.26583p ; **FLOATING
C1041 a_1043543_1125400# 0 3.29428f ; **FLOATING
C1042 a_155000_1131400# 0 0.26583p ; **FLOATING
C1043 a_151400_1125400# 0 3.29428f ; **FLOATING
C1044 a_1904286_1131400# 0 3.29428f
C1045 a_1047143_1137400# 0 0.26583p ; **FLOATING
C1046 a_1012143_1131400# 0 3.29428f
C1047 a_155000_1137400# 0 0.26583p ; **FLOATING
C1048 a_1047143_1143400# 0 0.26583p ; **FLOATING
C1049 a_1043543_1137400# 0 3.29428f ; **FLOATING
C1050 a_155000_1143400# 0 0.26583p ; **FLOATING
C1051 a_151400_1137400# 0 3.29428f ; **FLOATING
C1052 a_1904286_1143400# 0 3.29428f
C1053 a_1047143_1149400# 0 0.26583p ; **FLOATING
C1054 a_1012143_1143400# 0 3.29428f
C1055 a_155000_1149400# 0 0.26583p ; **FLOATING
C1056 a_1047143_1155400# 0 0.26583p ; **FLOATING
C1057 a_1043543_1149400# 0 3.29428f ; **FLOATING
C1058 a_155000_1155400# 0 0.26583p ; **FLOATING
C1059 a_151400_1149400# 0 3.29428f ; **FLOATING
C1060 a_1904286_1155400# 0 3.29428f
C1061 a_1047143_1161400# 0 0.26583p ; **FLOATING
C1062 a_1012143_1155400# 0 3.29428f
C1063 a_155000_1161400# 0 0.26583p ; **FLOATING
C1064 a_1047143_1167400# 0 0.26583p ; **FLOATING
C1065 a_1043543_1161400# 0 3.29428f ; **FLOATING
C1066 a_155000_1167400# 0 0.26583p ; **FLOATING
C1067 a_151400_1161400# 0 3.29428f ; **FLOATING
C1068 a_1904286_1167400# 0 3.29428f
C1069 a_1047143_1173400# 0 0.26583p ; **FLOATING
C1070 a_1012143_1167400# 0 3.29428f
C1071 a_155000_1173400# 0 0.26583p ; **FLOATING
C1072 a_1047143_1179400# 0 0.26583p ; **FLOATING
C1073 a_1043543_1173400# 0 3.29428f ; **FLOATING
C1074 a_155000_1179400# 0 0.26583p ; **FLOATING
C1075 a_151400_1173400# 0 3.29428f ; **FLOATING
C1076 a_1904286_1179400# 0 3.29428f
C1077 a_1047143_1185400# 0 0.26583p ; **FLOATING
C1078 a_1012143_1179400# 0 3.29428f
C1079 a_155000_1185400# 0 0.26583p ; **FLOATING
C1080 a_1047143_1191400# 0 0.26583p ; **FLOATING
C1081 a_1043543_1185400# 0 3.29428f ; **FLOATING
C1082 a_155000_1191400# 0 0.26583p ; **FLOATING
C1083 a_151400_1185400# 0 3.29428f ; **FLOATING
C1084 a_1904286_1191400# 0 3.29428f
C1085 a_1047143_1197400# 0 0.26583p ; **FLOATING
C1086 a_1012143_1191400# 0 3.29428f
C1087 a_155000_1197400# 0 0.26583p ; **FLOATING
C1088 a_1047143_1203400# 0 0.26583p ; **FLOATING
C1089 a_1043543_1197400# 0 3.29428f ; **FLOATING
C1090 a_155000_1203400# 0 0.26583p ; **FLOATING
C1091 a_151400_1197400# 0 3.29428f ; **FLOATING
C1092 a_1904286_1203400# 0 3.29428f
C1093 a_1047143_1209400# 0 0.26583p ; **FLOATING
C1094 a_1012143_1203400# 0 3.29428f
C1095 a_155000_1209400# 0 0.26583p ; **FLOATING
C1096 a_1047143_1215400# 0 0.26583p ; **FLOATING
C1097 a_1043543_1209400# 0 3.29428f ; **FLOATING
C1098 a_155000_1215400# 0 0.26583p ; **FLOATING
C1099 a_151400_1209400# 0 3.29428f ; **FLOATING
C1100 a_1904286_1215400# 0 3.29428f
C1101 a_1047143_1221400# 0 0.26583p ; **FLOATING
C1102 a_1012143_1215400# 0 3.29428f
C1103 a_155000_1221400# 0 0.26583p ; **FLOATING
C1104 a_1047143_1227400# 0 0.26583p ; **FLOATING
C1105 a_1043543_1221400# 0 3.29428f ; **FLOATING
C1106 a_155000_1227400# 0 0.26583p ; **FLOATING
C1107 a_151400_1221400# 0 3.29428f ; **FLOATING
C1108 a_1904286_1227400# 0 3.29428f
C1109 a_1047143_1233400# 0 0.26583p ; **FLOATING
C1110 a_1012143_1227400# 0 3.29428f
C1111 a_155000_1233400# 0 0.26583p ; **FLOATING
C1112 a_1047143_1239400# 0 0.26583p ; **FLOATING
C1113 a_1043543_1233400# 0 3.29428f ; **FLOATING
C1114 a_155000_1239400# 0 0.26583p ; **FLOATING
C1115 a_151400_1233400# 0 3.29428f ; **FLOATING
C1116 a_1904286_1239400# 0 3.29428f
C1117 a_1047143_1245400# 0 0.26583p ; **FLOATING
C1118 a_1012143_1239400# 0 3.29428f
C1119 a_155000_1245400# 0 0.26583p ; **FLOATING
C1120 a_1047143_1251400# 0 0.26583p ; **FLOATING
C1121 a_1043543_1245400# 0 3.29428f ; **FLOATING
C1122 a_155000_1251400# 0 0.26583p ; **FLOATING
C1123 a_151400_1245400# 0 3.29428f ; **FLOATING
C1124 a_1904286_1251400# 0 3.29428f
C1125 a_1047143_1257400# 0 0.26583p ; **FLOATING
C1126 a_1012143_1251400# 0 3.29428f
C1127 a_155000_1257400# 0 0.26583p ; **FLOATING
C1128 a_1047143_1263400# 0 0.26583p ; **FLOATING
C1129 a_1043543_1257400# 0 3.29428f ; **FLOATING
C1130 a_155000_1263400# 0 0.26583p ; **FLOATING
C1131 a_151400_1257400# 0 3.29428f ; **FLOATING
C1132 a_1904286_1263400# 0 3.29428f
C1133 a_1047143_1269400# 0 0.26583p ; **FLOATING
C1134 a_1012143_1263400# 0 3.29428f
C1135 a_155000_1269400# 0 0.26583p ; **FLOATING
C1136 a_1047143_1275400# 0 0.26583p ; **FLOATING
C1137 a_1043543_1269400# 0 3.29428f ; **FLOATING
C1138 a_155000_1275400# 0 0.26583p ; **FLOATING
C1139 a_151400_1269400# 0 3.29428f ; **FLOATING
C1140 a_1904286_1275400# 0 3.29428f
C1141 a_1047143_1281400# 0 0.26583p ; **FLOATING
C1142 a_1012143_1275400# 0 3.29428f
C1143 a_155000_1281400# 0 0.26583p ; **FLOATING
C1144 a_1047143_1287400# 0 0.26583p ; **FLOATING
C1145 a_1043543_1281400# 0 3.29428f ; **FLOATING
C1146 a_155000_1287400# 0 0.26583p ; **FLOATING
C1147 a_151400_1281400# 0 3.29428f ; **FLOATING
C1148 a_1904286_1287400# 0 3.29428f
C1149 a_1047143_1293400# 0 0.26583p ; **FLOATING
C1150 a_1012143_1287400# 0 3.29428f
C1151 a_155000_1293400# 0 0.26583p ; **FLOATING
C1152 a_1047143_1299400# 0 0.26583p ; **FLOATING
C1153 a_1043543_1293400# 0 3.29428f ; **FLOATING
C1154 a_155000_1299400# 0 0.26583p ; **FLOATING
C1155 a_151400_1293400# 0 3.29428f ; **FLOATING
C1156 a_1904286_1299400# 0 3.29428f
C1157 a_1047143_1305400# 0 0.26583p ; **FLOATING
C1158 a_1012143_1299400# 0 3.29428f
C1159 a_155000_1305400# 0 0.26583p ; **FLOATING
C1160 a_1047143_1311400# 0 0.26583p ; **FLOATING
C1161 a_1043543_1305400# 0 3.29428f ; **FLOATING
C1162 a_155000_1311400# 0 0.26583p ; **FLOATING
C1163 a_151400_1305400# 0 3.29428f ; **FLOATING
C1164 a_1904286_1311400# 0 3.29428f
C1165 a_1047143_1317400# 0 0.26583p ; **FLOATING
C1166 a_1012143_1311400# 0 3.29428f
C1167 a_155000_1317400# 0 0.26583p ; **FLOATING
C1168 a_1047143_1323400# 0 0.26583p ; **FLOATING
C1169 a_1043543_1317400# 0 3.29428f ; **FLOATING
C1170 a_155000_1323400# 0 0.26583p ; **FLOATING
C1171 a_151400_1317400# 0 3.29428f ; **FLOATING
C1172 a_1904286_1323400# 0 3.29428f
C1173 a_1047143_1329400# 0 0.26583p ; **FLOATING
C1174 a_1012143_1323400# 0 3.29428f
C1175 a_155000_1329400# 0 0.26583p ; **FLOATING
C1176 a_1047143_1335400# 0 0.26583p ; **FLOATING
C1177 a_1043543_1329400# 0 3.29428f ; **FLOATING
C1178 a_155000_1335400# 0 0.26583p ; **FLOATING
C1179 a_151400_1329400# 0 3.29428f ; **FLOATING
C1180 a_1904286_1335400# 0 3.33625f
C1181 a_1047143_1341400# 0 0.26972p ; **FLOATING
C1182 a_1012143_1335400# 0 3.33625f
C1183 a_155000_1341400# 0 0.26972p ; **FLOATING
C1184 a_151400_1341400# 0 0.29152p ; **FLOATING
XR0A a_229000_363000# a_1047143_747400# RPP W=2.4e-06 L=0.0004285715
XR0B a_1047143_747400# a_1904286_747400# RPP W=2.4e-06 L=0.0004285715
XR1A a_151400_747400# a_155000_747400# RPP W=2.4e-06 L=0.0004285715
XR1B a_155000_747400# a_1012143_747400# RPP W=2.4e-06 L=0.0004285715
XR2A a_1043543_753400# a_1047143_753400# RPP W=2.4e-06 L=0.0004285715
XR2B a_1047143_753400# a_1904286_747400# RPP W=2.4e-06 L=0.0004285715
XR3A a_151400_753400# a_155000_753400# RPP W=2.4e-06 L=0.0004285715
XR3B a_155000_753400# a_1012143_747400# RPP W=2.4e-06 L=0.0004285715
XR4A a_1043543_753400# a_1047143_759400# RPP W=2.4e-06 L=0.0004285715
XR4B a_1047143_759400# a_1904286_759400# RPP W=2.4e-06 L=0.0004285715
XR5A a_151400_753400# a_155000_759400# RPP W=2.4e-06 L=0.0004285715
XR5B a_155000_759400# a_1012143_759400# RPP W=2.4e-06 L=0.0004285715
XR6A a_1043543_765400# a_1047143_765400# RPP W=2.4e-06 L=0.0004285715
XR6B a_1047143_765400# a_1904286_759400# RPP W=2.4e-06 L=0.0004285715
XR7A a_151400_765400# a_155000_765400# RPP W=2.4e-06 L=0.0004285715
XR7B a_155000_765400# a_1012143_759400# RPP W=2.4e-06 L=0.0004285715
XR8A a_1043543_765400# a_1047143_771400# RPP W=2.4e-06 L=0.0004285715
XR8B a_1047143_771400# a_1904286_771400# RPP W=2.4e-06 L=0.0004285715
XR9A a_151400_765400# a_155000_771400# RPP W=2.4e-06 L=0.0004285715
XR9B a_155000_771400# a_1012143_771400# RPP W=2.4e-06 L=0.0004285715
XR10A a_1043543_777400# a_1047143_777400# RPP W=2.4e-06 L=0.0004285715
XR10B a_1047143_777400# a_1904286_771400# RPP W=2.4e-06 L=0.0004285715
XR11A a_151400_777400# a_155000_777400# RPP W=2.4e-06 L=0.0004285715
XR11B a_155000_777400# a_1012143_771400# RPP W=2.4e-06 L=0.0004285715
XR12A a_1043543_777400# a_1047143_783400# RPP W=2.4e-06 L=0.0004285715
XR12B a_1047143_783400# a_1904286_783400# RPP W=2.4e-06 L=0.0004285715
XR13A a_151400_777400# a_155000_783400# RPP W=2.4e-06 L=0.0004285715
XR13B a_155000_783400# a_1012143_783400# RPP W=2.4e-06 L=0.0004285715
XR14A a_1043543_789400# a_1047143_789400# RPP W=2.4e-06 L=0.0004285715
XR14B a_1047143_789400# a_1904286_783400# RPP W=2.4e-06 L=0.0004285715
XR15A a_151400_789400# a_155000_789400# RPP W=2.4e-06 L=0.0004285715
XR15B a_155000_789400# a_1012143_783400# RPP W=2.4e-06 L=0.0004285715
XR16A a_1043543_789400# a_1047143_795400# RPP W=2.4e-06 L=0.0004285715
XR16B a_1047143_795400# a_1904286_795400# RPP W=2.4e-06 L=0.0004285715
XR17A a_151400_789400# a_155000_795400# RPP W=2.4e-06 L=0.0004285715
XR17B a_155000_795400# a_1012143_795400# RPP W=2.4e-06 L=0.0004285715
XR18A a_1043543_801400# a_1047143_801400# RPP W=2.4e-06 L=0.0004285715
XR18B a_1047143_801400# a_1904286_795400# RPP W=2.4e-06 L=0.0004285715
XR19A a_151400_801400# a_155000_801400# RPP W=2.4e-06 L=0.0004285715
XR19B a_155000_801400# a_1012143_795400# RPP W=2.4e-06 L=0.0004285715
XR20A a_1043543_801400# a_1047143_807400# RPP W=2.4e-06 L=0.0004285715
XR20B a_1047143_807400# a_1904286_807400# RPP W=2.4e-06 L=0.0004285715
XR21A a_151400_801400# a_155000_807400# RPP W=2.4e-06 L=0.0004285715
XR21B a_155000_807400# a_1012143_807400# RPP W=2.4e-06 L=0.0004285715
XR22A a_1043543_813400# a_1047143_813400# RPP W=2.4e-06 L=0.0004285715
XR22B a_1047143_813400# a_1904286_807400# RPP W=2.4e-06 L=0.0004285715
XR23A a_151400_813400# a_155000_813400# RPP W=2.4e-06 L=0.0004285715
XR23B a_155000_813400# a_1012143_807400# RPP W=2.4e-06 L=0.0004285715
XR24A a_1043543_813400# a_1047143_819400# RPP W=2.4e-06 L=0.0004285715
XR24B a_1047143_819400# a_1904286_819400# RPP W=2.4e-06 L=0.0004285715
XR25A a_151400_813400# a_155000_819400# RPP W=2.4e-06 L=0.0004285715
XR25B a_155000_819400# a_1012143_819400# RPP W=2.4e-06 L=0.0004285715
XR26A a_1043543_825400# a_1047143_825400# RPP W=2.4e-06 L=0.0004285715
XR26B a_1047143_825400# a_1904286_819400# RPP W=2.4e-06 L=0.0004285715
XR27A a_151400_825400# a_155000_825400# RPP W=2.4e-06 L=0.0004285715
XR27B a_155000_825400# a_1012143_819400# RPP W=2.4e-06 L=0.0004285715
XR28A a_1043543_825400# a_1047143_831400# RPP W=2.4e-06 L=0.0004285715
XR28B a_1047143_831400# a_1904286_831400# RPP W=2.4e-06 L=0.0004285715
XR29A a_151400_825400# a_155000_831400# RPP W=2.4e-06 L=0.0004285715
XR29B a_155000_831400# a_1012143_831400# RPP W=2.4e-06 L=0.0004285715
XR30A a_1043543_837400# a_1047143_837400# RPP W=2.4e-06 L=0.0004285715
XR30B a_1047143_837400# a_1904286_831400# RPP W=2.4e-06 L=0.0004285715
XR31A a_151400_837400# a_155000_837400# RPP W=2.4e-06 L=0.0004285715
XR31B a_155000_837400# a_1012143_831400# RPP W=2.4e-06 L=0.0004285715
XR32A a_1043543_837400# a_1047143_843400# RPP W=2.4e-06 L=0.0004285715
XR32B a_1047143_843400# a_1904286_843400# RPP W=2.4e-06 L=0.0004285715
XR33A a_151400_837400# a_155000_843400# RPP W=2.4e-06 L=0.0004285715
XR33B a_155000_843400# a_1012143_843400# RPP W=2.4e-06 L=0.0004285715
XR34A a_1043543_849400# a_1047143_849400# RPP W=2.4e-06 L=0.0004285715
XR34B a_1047143_849400# a_1904286_843400# RPP W=2.4e-06 L=0.0004285715
XR35A a_151400_849400# a_155000_849400# RPP W=2.4e-06 L=0.0004285715
XR35B a_155000_849400# a_1012143_843400# RPP W=2.4e-06 L=0.0004285715
XR36A a_1043543_849400# a_1047143_855400# RPP W=2.4e-06 L=0.0004285715
XR36B a_1047143_855400# a_1904286_855400# RPP W=2.4e-06 L=0.0004285715
XR37A a_151400_849400# a_155000_855400# RPP W=2.4e-06 L=0.0004285715
XR37B a_155000_855400# a_1012143_855400# RPP W=2.4e-06 L=0.0004285715
XR38A a_1043543_861400# a_1047143_861400# RPP W=2.4e-06 L=0.0004285715
XR38B a_1047143_861400# a_1904286_855400# RPP W=2.4e-06 L=0.0004285715
XR39A a_151400_861400# a_155000_861400# RPP W=2.4e-06 L=0.0004285715
XR39B a_155000_861400# a_1012143_855400# RPP W=2.4e-06 L=0.0004285715
XR40A a_1043543_861400# a_1047143_867400# RPP W=2.4e-06 L=0.0004285715
XR40B a_1047143_867400# a_1904286_867400# RPP W=2.4e-06 L=0.0004285715
XR41A a_151400_861400# a_155000_867400# RPP W=2.4e-06 L=0.0004285715
XR41B a_155000_867400# a_1012143_867400# RPP W=2.4e-06 L=0.0004285715
XR42A a_1043543_873400# a_1047143_873400# RPP W=2.4e-06 L=0.0004285715
XR42B a_1047143_873400# a_1904286_867400# RPP W=2.4e-06 L=0.0004285715
XR43A a_151400_873400# a_155000_873400# RPP W=2.4e-06 L=0.0004285715
XR43B a_155000_873400# a_1012143_867400# RPP W=2.4e-06 L=0.0004285715
XR44A a_1043543_873400# a_1047143_879400# RPP W=2.4e-06 L=0.0004285715
XR44B a_1047143_879400# a_1904286_879400# RPP W=2.4e-06 L=0.0004285715
XR45A a_151400_873400# a_155000_879400# RPP W=2.4e-06 L=0.0004285715
XR45B a_155000_879400# a_1012143_879400# RPP W=2.4e-06 L=0.0004285715
XR46A a_1043543_885400# a_1047143_885400# RPP W=2.4e-06 L=0.0004285715
XR46B a_1047143_885400# a_1904286_879400# RPP W=2.4e-06 L=0.0004285715
XR47A a_151400_885400# a_155000_885400# RPP W=2.4e-06 L=0.0004285715
XR47B a_155000_885400# a_1012143_879400# RPP W=2.4e-06 L=0.0004285715
XR48A a_1043543_885400# a_1047143_891400# RPP W=2.4e-06 L=0.0004285715
XR48B a_1047143_891400# a_1904286_891400# RPP W=2.4e-06 L=0.0004285715
XR49A a_151400_885400# a_155000_891400# RPP W=2.4e-06 L=0.0004285715
XR49B a_155000_891400# a_1012143_891400# RPP W=2.4e-06 L=0.0004285715
XR50A a_1043543_897400# a_1047143_897400# RPP W=2.4e-06 L=0.0004285715
XR50B a_1047143_897400# a_1904286_891400# RPP W=2.4e-06 L=0.0004285715
XR51A a_151400_897400# a_155000_897400# RPP W=2.4e-06 L=0.0004285715
XR51B a_155000_897400# a_1012143_891400# RPP W=2.4e-06 L=0.0004285715
XR52A a_1043543_897400# a_1047143_903400# RPP W=2.4e-06 L=0.0004285715
XR52B a_1047143_903400# a_1904286_903400# RPP W=2.4e-06 L=0.0004285715
XR53A a_151400_897400# a_155000_903400# RPP W=2.4e-06 L=0.0004285715
XR53B a_155000_903400# a_1012143_903400# RPP W=2.4e-06 L=0.0004285715
XR54A a_1043543_909400# a_1047143_909400# RPP W=2.4e-06 L=0.0004285715
XR54B a_1047143_909400# a_1904286_903400# RPP W=2.4e-06 L=0.0004285715
XR55A a_151400_909400# a_155000_909400# RPP W=2.4e-06 L=0.0004285715
XR55B a_155000_909400# a_1012143_903400# RPP W=2.4e-06 L=0.0004285715
XR56A a_1043543_909400# a_1047143_915400# RPP W=2.4e-06 L=0.0004285715
XR56B a_1047143_915400# a_1904286_915400# RPP W=2.4e-06 L=0.0004285715
XR57A a_151400_909400# a_155000_915400# RPP W=2.4e-06 L=0.0004285715
XR57B a_155000_915400# a_1012143_915400# RPP W=2.4e-06 L=0.0004285715
XR58A a_1043543_921400# a_1047143_921400# RPP W=2.4e-06 L=0.0004285715
XR58B a_1047143_921400# a_1904286_915400# RPP W=2.4e-06 L=0.0004285715
XR59A a_151400_921400# a_155000_921400# RPP W=2.4e-06 L=0.0004285715
XR59B a_155000_921400# a_1012143_915400# RPP W=2.4e-06 L=0.0004285715
XR60A a_1043543_921400# a_1047143_927400# RPP W=2.4e-06 L=0.0004285715
XR60B a_1047143_927400# a_1904286_927400# RPP W=2.4e-06 L=0.0004285715
XR61A a_151400_921400# a_155000_927400# RPP W=2.4e-06 L=0.0004285715
XR61B a_155000_927400# a_1012143_927400# RPP W=2.4e-06 L=0.0004285715
XR62A a_1043543_933400# a_1047143_933400# RPP W=2.4e-06 L=0.0004285715
XR62B a_1047143_933400# a_1904286_927400# RPP W=2.4e-06 L=0.0004285715
XR63A a_151400_933400# a_155000_933400# RPP W=2.4e-06 L=0.0004285715
XR63B a_155000_933400# a_1012143_927400# RPP W=2.4e-06 L=0.0004285715
XR64A a_1043543_933400# a_1047143_939400# RPP W=2.4e-06 L=0.0004285715
XR64B a_1047143_939400# a_1904286_939400# RPP W=2.4e-06 L=0.0004285715
XR65A a_151400_933400# a_155000_939400# RPP W=2.4e-06 L=0.0004285715
XR65B a_155000_939400# a_1012143_939400# RPP W=2.4e-06 L=0.0004285715
XR66A a_1043543_945400# a_1047143_945400# RPP W=2.4e-06 L=0.0004285715
XR66B a_1047143_945400# a_1904286_939400# RPP W=2.4e-06 L=0.0004285715
XR67A a_151400_945400# a_155000_945400# RPP W=2.4e-06 L=0.0004285715
XR67B a_155000_945400# a_1012143_939400# RPP W=2.4e-06 L=0.0004285715
XR68A a_1043543_945400# a_1047143_951400# RPP W=2.4e-06 L=0.0004285715
XR68B a_1047143_951400# a_1904286_951400# RPP W=2.4e-06 L=0.0004285715
XR69A a_151400_945400# a_155000_951400# RPP W=2.4e-06 L=0.0004285715
XR69B a_155000_951400# a_1012143_951400# RPP W=2.4e-06 L=0.0004285715
XR70A a_1043543_957400# a_1047143_957400# RPP W=2.4e-06 L=0.0004285715
XR70B a_1047143_957400# a_1904286_951400# RPP W=2.4e-06 L=0.0004285715
XR71A a_151400_957400# a_155000_957400# RPP W=2.4e-06 L=0.0004285715
XR71B a_155000_957400# a_1012143_951400# RPP W=2.4e-06 L=0.0004285715
XR72A a_1043543_957400# a_1047143_963400# RPP W=2.4e-06 L=0.0004285715
XR72B a_1047143_963400# a_1904286_963400# RPP W=2.4e-06 L=0.0004285715
XR73A a_151400_957400# a_155000_963400# RPP W=2.4e-06 L=0.0004285715
XR73B a_155000_963400# a_1012143_963400# RPP W=2.4e-06 L=0.0004285715
XR74A a_1043543_969400# a_1047143_969400# RPP W=2.4e-06 L=0.0004285715
XR74B a_1047143_969400# a_1904286_963400# RPP W=2.4e-06 L=0.0004285715
XR75A a_151400_969400# a_155000_969400# RPP W=2.4e-06 L=0.0004285715
XR75B a_155000_969400# a_1012143_963400# RPP W=2.4e-06 L=0.0004285715
XR76A a_1043543_969400# a_1047143_975400# RPP W=2.4e-06 L=0.0004285715
XR76B a_1047143_975400# a_1904286_975400# RPP W=2.4e-06 L=0.0004285715
XR77A a_151400_969400# a_155000_975400# RPP W=2.4e-06 L=0.0004285715
XR77B a_155000_975400# a_1012143_975400# RPP W=2.4e-06 L=0.0004285715
XR78A a_1043543_981400# a_1047143_981400# RPP W=2.4e-06 L=0.0004285715
XR78B a_1047143_981400# a_1904286_975400# RPP W=2.4e-06 L=0.0004285715
XR79A a_151400_981400# a_155000_981400# RPP W=2.4e-06 L=0.0004285715
XR79B a_155000_981400# a_1012143_975400# RPP W=2.4e-06 L=0.0004285715
XR80A a_1043543_981400# a_1047143_987400# RPP W=2.4e-06 L=0.0004285715
XR80B a_1047143_987400# a_1904286_987400# RPP W=2.4e-06 L=0.0004285715
XR81A a_151400_981400# a_155000_987400# RPP W=2.4e-06 L=0.0004285715
XR81B a_155000_987400# a_1012143_987400# RPP W=2.4e-06 L=0.0004285715
XR82A a_1043543_993400# a_1047143_993400# RPP W=2.4e-06 L=0.0004285715
XR82B a_1047143_993400# a_1904286_987400# RPP W=2.4e-06 L=0.0004285715
XR83A a_151400_993400# a_155000_993400# RPP W=2.4e-06 L=0.0004285715
XR83B a_155000_993400# a_1012143_987400# RPP W=2.4e-06 L=0.0004285715
XR84A a_1043543_993400# a_1047143_999400# RPP W=2.4e-06 L=0.0004285715
XR84B a_1047143_999400# a_1904286_999400# RPP W=2.4e-06 L=0.0004285715
XR85A a_151400_993400# a_155000_999400# RPP W=2.4e-06 L=0.0004285715
XR85B a_155000_999400# a_1012143_999400# RPP W=2.4e-06 L=0.0004285715
XR86A a_1043543_1005400# a_1047143_1005400# RPP W=2.4e-06 L=0.0004285715
XR86B a_1047143_1005400# a_1904286_999400# RPP W=2.4e-06 L=0.0004285715
XR87A a_151400_1005400# a_155000_1005400# RPP W=2.4e-06 L=0.0004285715
XR87B a_155000_1005400# a_1012143_999400# RPP W=2.4e-06 L=0.0004285715
XR88A a_1043543_1005400# a_1047143_1011400# RPP W=2.4e-06 L=0.0004285715
XR88B a_1047143_1011400# a_1904286_1011400# RPP W=2.4e-06 L=0.0004285715
XR89A a_151400_1005400# a_155000_1011400# RPP W=2.4e-06 L=0.0004285715
XR89B a_155000_1011400# a_1012143_1011400# RPP W=2.4e-06 L=0.0004285715
XR90A a_1043543_1017400# a_1047143_1017400# RPP W=2.4e-06 L=0.0004285715
XR90B a_1047143_1017400# a_1904286_1011400# RPP W=2.4e-06 L=0.0004285715
XR91A a_151400_1017400# a_155000_1017400# RPP W=2.4e-06 L=0.0004285715
XR91B a_155000_1017400# a_1012143_1011400# RPP W=2.4e-06 L=0.0004285715
XR92A a_1043543_1017400# a_1047143_1023400# RPP W=2.4e-06 L=0.0004285715
XR92B a_1047143_1023400# a_1904286_1023400# RPP W=2.4e-06 L=0.0004285715
XR93A a_151400_1017400# a_155000_1023400# RPP W=2.4e-06 L=0.0004285715
XR93B a_155000_1023400# a_1012143_1023400# RPP W=2.4e-06 L=0.0004285715
XR94A a_1043543_1029400# a_1047143_1029400# RPP W=2.4e-06 L=0.0004285715
XR94B a_1047143_1029400# a_1904286_1023400# RPP W=2.4e-06 L=0.0004285715
XR95A a_151400_1029400# a_155000_1029400# RPP W=2.4e-06 L=0.0004285715
XR95B a_155000_1029400# a_1012143_1023400# RPP W=2.4e-06 L=0.0004285715
XR96A a_1043543_1029400# a_1047143_1035400# RPP W=2.4e-06 L=0.0004285715
XR96B a_1047143_1035400# a_1904286_1035400# RPP W=2.4e-06 L=0.0004285715
XR97A a_151400_1029400# a_155000_1035400# RPP W=2.4e-06 L=0.0004285715
XR97B a_155000_1035400# a_1012143_1035400# RPP W=2.4e-06 L=0.0004285715
XR98A a_1043543_1041400# a_1047143_1041400# RPP W=2.4e-06 L=0.0004285715
XR98B a_1047143_1041400# a_1904286_1035400# RPP W=2.4e-06 L=0.0004285715
XR99A a_151400_1041400# a_155000_1041400# RPP W=2.4e-06 L=0.0004285715
XR99B a_155000_1041400# a_1012143_1035400# RPP W=2.4e-06 L=0.0004285715
XR100A a_1043543_1041400# a_1047143_1047400# RPP W=2.4e-06 L=0.0004285715
XR100B a_1047143_1047400# a_1904286_1047400# RPP W=2.4e-06 L=0.0004285715
XR101A a_151400_1041400# a_155000_1047400# RPP W=2.4e-06 L=0.0004285715
XR101B a_155000_1047400# a_1012143_1047400# RPP W=2.4e-06 L=0.0004285715
XR102A a_1043543_1053400# a_1047143_1053400# RPP W=2.4e-06 L=0.0004285715
XR102B a_1047143_1053400# a_1904286_1047400# RPP W=2.4e-06 L=0.0004285715
XR103A a_151400_1053400# a_155000_1053400# RPP W=2.4e-06 L=0.0004285715
XR103B a_155000_1053400# a_1012143_1047400# RPP W=2.4e-06 L=0.0004285715
XR104A a_1043543_1053400# a_1047143_1059400# RPP W=2.4e-06 L=0.0004285715
XR104B a_1047143_1059400# a_1904286_1059400# RPP W=2.4e-06 L=0.0004285715
XR105A a_151400_1053400# a_155000_1059400# RPP W=2.4e-06 L=0.0004285715
XR105B a_155000_1059400# a_1012143_1059400# RPP W=2.4e-06 L=0.0004285715
XR106A a_1043543_1065400# a_1047143_1065400# RPP W=2.4e-06 L=0.0004285715
XR106B a_1047143_1065400# a_1904286_1059400# RPP W=2.4e-06 L=0.0004285715
XR107A a_151400_1065400# a_155000_1065400# RPP W=2.4e-06 L=0.0004285715
XR107B a_155000_1065400# a_1012143_1059400# RPP W=2.4e-06 L=0.0004285715
XR108A a_1043543_1065400# a_1047143_1071400# RPP W=2.4e-06 L=0.0004285715
XR108B a_1047143_1071400# a_1904286_1071400# RPP W=2.4e-06 L=0.0004285715
XR109A a_151400_1065400# a_155000_1071400# RPP W=2.4e-06 L=0.0004285715
XR109B a_155000_1071400# a_1012143_1071400# RPP W=2.4e-06 L=0.0004285715
XR110A a_1043543_1077400# a_1047143_1077400# RPP W=2.4e-06 L=0.0004285715
XR110B a_1047143_1077400# a_1904286_1071400# RPP W=2.4e-06 L=0.0004285715
XR111A a_151400_1077400# a_155000_1077400# RPP W=2.4e-06 L=0.0004285715
XR111B a_155000_1077400# a_1012143_1071400# RPP W=2.4e-06 L=0.0004285715
XR112A a_1043543_1077400# a_1047143_1083400# RPP W=2.4e-06 L=0.0004285715
XR112B a_1047143_1083400# a_1904286_1083400# RPP W=2.4e-06 L=0.0004285715
XR113A a_151400_1077400# a_155000_1083400# RPP W=2.4e-06 L=0.0004285715
XR113B a_155000_1083400# a_1012143_1083400# RPP W=2.4e-06 L=0.0004285715
XR114A a_1043543_1089400# a_1047143_1089400# RPP W=2.4e-06 L=0.0004285715
XR114B a_1047143_1089400# a_1904286_1083400# RPP W=2.4e-06 L=0.0004285715
XR115A a_151400_1089400# a_155000_1089400# RPP W=2.4e-06 L=0.0004285715
XR115B a_155000_1089400# a_1012143_1083400# RPP W=2.4e-06 L=0.0004285715
XR116A a_1043543_1089400# a_1047143_1095400# RPP W=2.4e-06 L=0.0004285715
XR116B a_1047143_1095400# a_1904286_1095400# RPP W=2.4e-06 L=0.0004285715
XR117A a_151400_1089400# a_155000_1095400# RPP W=2.4e-06 L=0.0004285715
XR117B a_155000_1095400# a_1012143_1095400# RPP W=2.4e-06 L=0.0004285715
XR118A a_1043543_1101400# a_1047143_1101400# RPP W=2.4e-06 L=0.0004285715
XR118B a_1047143_1101400# a_1904286_1095400# RPP W=2.4e-06 L=0.0004285715
XR119A a_151400_1101400# a_155000_1101400# RPP W=2.4e-06 L=0.0004285715
XR119B a_155000_1101400# a_1012143_1095400# RPP W=2.4e-06 L=0.0004285715
XR120A a_1043543_1101400# a_1047143_1107400# RPP W=2.4e-06 L=0.0004285715
XR120B a_1047143_1107400# a_1904286_1107400# RPP W=2.4e-06 L=0.0004285715
XR121A a_151400_1101400# a_155000_1107400# RPP W=2.4e-06 L=0.0004285715
XR121B a_155000_1107400# a_1012143_1107400# RPP W=2.4e-06 L=0.0004285715
XR122A a_1043543_1113400# a_1047143_1113400# RPP W=2.4e-06 L=0.0004285715
XR122B a_1047143_1113400# a_1904286_1107400# RPP W=2.4e-06 L=0.0004285715
XR123A a_151400_1113400# a_155000_1113400# RPP W=2.4e-06 L=0.0004285715
XR123B a_155000_1113400# a_1012143_1107400# RPP W=2.4e-06 L=0.0004285715
XR124A a_1043543_1113400# a_1047143_1119400# RPP W=2.4e-06 L=0.0004285715
XR124B a_1047143_1119400# a_1904286_1119400# RPP W=2.4e-06 L=0.0004285715
XR125A a_151400_1113400# a_155000_1119400# RPP W=2.4e-06 L=0.0004285715
XR125B a_155000_1119400# a_1012143_1119400# RPP W=2.4e-06 L=0.0004285715
XR126A a_1043543_1125400# a_1047143_1125400# RPP W=2.4e-06 L=0.0004285715
XR126B a_1047143_1125400# a_1904286_1119400# RPP W=2.4e-06 L=0.0004285715
XR127A a_151400_1125400# a_155000_1125400# RPP W=2.4e-06 L=0.0004285715
XR127B a_155000_1125400# a_1012143_1119400# RPP W=2.4e-06 L=0.0004285715
XR128A a_1043543_1125400# a_1047143_1131400# RPP W=2.4e-06 L=0.0004285715
XR128B a_1047143_1131400# a_1904286_1131400# RPP W=2.4e-06 L=0.0004285715
XR129A a_151400_1125400# a_155000_1131400# RPP W=2.4e-06 L=0.0004285715
XR129B a_155000_1131400# a_1012143_1131400# RPP W=2.4e-06 L=0.0004285715
XR130A a_1043543_1137400# a_1047143_1137400# RPP W=2.4e-06 L=0.0004285715
XR130B a_1047143_1137400# a_1904286_1131400# RPP W=2.4e-06 L=0.0004285715
XR131A a_151400_1137400# a_155000_1137400# RPP W=2.4e-06 L=0.0004285715
XR131B a_155000_1137400# a_1012143_1131400# RPP W=2.4e-06 L=0.0004285715
XR132A a_1043543_1137400# a_1047143_1143400# RPP W=2.4e-06 L=0.0004285715
XR132B a_1047143_1143400# a_1904286_1143400# RPP W=2.4e-06 L=0.0004285715
XR133A a_151400_1137400# a_155000_1143400# RPP W=2.4e-06 L=0.0004285715
XR133B a_155000_1143400# a_1012143_1143400# RPP W=2.4e-06 L=0.0004285715
XR134A a_1043543_1149400# a_1047143_1149400# RPP W=2.4e-06 L=0.0004285715
XR134B a_1047143_1149400# a_1904286_1143400# RPP W=2.4e-06 L=0.0004285715
XR135A a_151400_1149400# a_155000_1149400# RPP W=2.4e-06 L=0.0004285715
XR135B a_155000_1149400# a_1012143_1143400# RPP W=2.4e-06 L=0.0004285715
XR136A a_1043543_1149400# a_1047143_1155400# RPP W=2.4e-06 L=0.0004285715
XR136B a_1047143_1155400# a_1904286_1155400# RPP W=2.4e-06 L=0.0004285715
XR137A a_151400_1149400# a_155000_1155400# RPP W=2.4e-06 L=0.0004285715
XR137B a_155000_1155400# a_1012143_1155400# RPP W=2.4e-06 L=0.0004285715
XR138A a_1043543_1161400# a_1047143_1161400# RPP W=2.4e-06 L=0.0004285715
XR138B a_1047143_1161400# a_1904286_1155400# RPP W=2.4e-06 L=0.0004285715
XR139A a_151400_1161400# a_155000_1161400# RPP W=2.4e-06 L=0.0004285715
XR139B a_155000_1161400# a_1012143_1155400# RPP W=2.4e-06 L=0.0004285715
XR140A a_1043543_1161400# a_1047143_1167400# RPP W=2.4e-06 L=0.0004285715
XR140B a_1047143_1167400# a_1904286_1167400# RPP W=2.4e-06 L=0.0004285715
XR141A a_151400_1161400# a_155000_1167400# RPP W=2.4e-06 L=0.0004285715
XR141B a_155000_1167400# a_1012143_1167400# RPP W=2.4e-06 L=0.0004285715
XR142A a_1043543_1173400# a_1047143_1173400# RPP W=2.4e-06 L=0.0004285715
XR142B a_1047143_1173400# a_1904286_1167400# RPP W=2.4e-06 L=0.0004285715
XR143A a_151400_1173400# a_155000_1173400# RPP W=2.4e-06 L=0.0004285715
XR143B a_155000_1173400# a_1012143_1167400# RPP W=2.4e-06 L=0.0004285715
XR144A a_1043543_1173400# a_1047143_1179400# RPP W=2.4e-06 L=0.0004285715
XR144B a_1047143_1179400# a_1904286_1179400# RPP W=2.4e-06 L=0.0004285715
XR145A a_151400_1173400# a_155000_1179400# RPP W=2.4e-06 L=0.0004285715
XR145B a_155000_1179400# a_1012143_1179400# RPP W=2.4e-06 L=0.0004285715
XR146A a_1043543_1185400# a_1047143_1185400# RPP W=2.4e-06 L=0.0004285715
XR146B a_1047143_1185400# a_1904286_1179400# RPP W=2.4e-06 L=0.0004285715
XR147A a_151400_1185400# a_155000_1185400# RPP W=2.4e-06 L=0.0004285715
XR147B a_155000_1185400# a_1012143_1179400# RPP W=2.4e-06 L=0.0004285715
XR148A a_1043543_1185400# a_1047143_1191400# RPP W=2.4e-06 L=0.0004285715
XR148B a_1047143_1191400# a_1904286_1191400# RPP W=2.4e-06 L=0.0004285715
XR149A a_151400_1185400# a_155000_1191400# RPP W=2.4e-06 L=0.0004285715
XR149B a_155000_1191400# a_1012143_1191400# RPP W=2.4e-06 L=0.0004285715
XR150A a_1043543_1197400# a_1047143_1197400# RPP W=2.4e-06 L=0.0004285715
XR150B a_1047143_1197400# a_1904286_1191400# RPP W=2.4e-06 L=0.0004285715
XR151A a_151400_1197400# a_155000_1197400# RPP W=2.4e-06 L=0.0004285715
XR151B a_155000_1197400# a_1012143_1191400# RPP W=2.4e-06 L=0.0004285715
XR152A a_1043543_1197400# a_1047143_1203400# RPP W=2.4e-06 L=0.0004285715
XR152B a_1047143_1203400# a_1904286_1203400# RPP W=2.4e-06 L=0.0004285715
XR153A a_151400_1197400# a_155000_1203400# RPP W=2.4e-06 L=0.0004285715
XR153B a_155000_1203400# a_1012143_1203400# RPP W=2.4e-06 L=0.0004285715
XR154A a_1043543_1209400# a_1047143_1209400# RPP W=2.4e-06 L=0.0004285715
XR154B a_1047143_1209400# a_1904286_1203400# RPP W=2.4e-06 L=0.0004285715
XR155A a_151400_1209400# a_155000_1209400# RPP W=2.4e-06 L=0.0004285715
XR155B a_155000_1209400# a_1012143_1203400# RPP W=2.4e-06 L=0.0004285715
XR156A a_1043543_1209400# a_1047143_1215400# RPP W=2.4e-06 L=0.0004285715
XR156B a_1047143_1215400# a_1904286_1215400# RPP W=2.4e-06 L=0.0004285715
XR157A a_151400_1209400# a_155000_1215400# RPP W=2.4e-06 L=0.0004285715
XR157B a_155000_1215400# a_1012143_1215400# RPP W=2.4e-06 L=0.0004285715
XR158A a_1043543_1221400# a_1047143_1221400# RPP W=2.4e-06 L=0.0004285715
XR158B a_1047143_1221400# a_1904286_1215400# RPP W=2.4e-06 L=0.0004285715
XR159A a_151400_1221400# a_155000_1221400# RPP W=2.4e-06 L=0.0004285715
XR159B a_155000_1221400# a_1012143_1215400# RPP W=2.4e-06 L=0.0004285715
XR160A a_1043543_1221400# a_1047143_1227400# RPP W=2.4e-06 L=0.0004285715
XR160B a_1047143_1227400# a_1904286_1227400# RPP W=2.4e-06 L=0.0004285715
XR161A a_151400_1221400# a_155000_1227400# RPP W=2.4e-06 L=0.0004285715
XR161B a_155000_1227400# a_1012143_1227400# RPP W=2.4e-06 L=0.0004285715
XR162A a_1043543_1233400# a_1047143_1233400# RPP W=2.4e-06 L=0.0004285715
XR162B a_1047143_1233400# a_1904286_1227400# RPP W=2.4e-06 L=0.0004285715
XR163A a_151400_1233400# a_155000_1233400# RPP W=2.4e-06 L=0.0004285715
XR163B a_155000_1233400# a_1012143_1227400# RPP W=2.4e-06 L=0.0004285715
XR164A a_1043543_1233400# a_1047143_1239400# RPP W=2.4e-06 L=0.0004285715
XR164B a_1047143_1239400# a_1904286_1239400# RPP W=2.4e-06 L=0.0004285715
XR165A a_151400_1233400# a_155000_1239400# RPP W=2.4e-06 L=0.0004285715
XR165B a_155000_1239400# a_1012143_1239400# RPP W=2.4e-06 L=0.0004285715
XR166A a_1043543_1245400# a_1047143_1245400# RPP W=2.4e-06 L=0.0004285715
XR166B a_1047143_1245400# a_1904286_1239400# RPP W=2.4e-06 L=0.0004285715
XR167A a_151400_1245400# a_155000_1245400# RPP W=2.4e-06 L=0.0004285715
XR167B a_155000_1245400# a_1012143_1239400# RPP W=2.4e-06 L=0.0004285715
XR168A a_1043543_1245400# a_1047143_1251400# RPP W=2.4e-06 L=0.0004285715
XR168B a_1047143_1251400# a_1904286_1251400# RPP W=2.4e-06 L=0.0004285715
XR169A a_151400_1245400# a_155000_1251400# RPP W=2.4e-06 L=0.0004285715
XR169B a_155000_1251400# a_1012143_1251400# RPP W=2.4e-06 L=0.0004285715
XR170A a_1043543_1257400# a_1047143_1257400# RPP W=2.4e-06 L=0.0004285715
XR170B a_1047143_1257400# a_1904286_1251400# RPP W=2.4e-06 L=0.0004285715
XR171A a_151400_1257400# a_155000_1257400# RPP W=2.4e-06 L=0.0004285715
XR171B a_155000_1257400# a_1012143_1251400# RPP W=2.4e-06 L=0.0004285715
XR172A a_1043543_1257400# a_1047143_1263400# RPP W=2.4e-06 L=0.0004285715
XR172B a_1047143_1263400# a_1904286_1263400# RPP W=2.4e-06 L=0.0004285715
XR173A a_151400_1257400# a_155000_1263400# RPP W=2.4e-06 L=0.0004285715
XR173B a_155000_1263400# a_1012143_1263400# RPP W=2.4e-06 L=0.0004285715
XR174A a_1043543_1269400# a_1047143_1269400# RPP W=2.4e-06 L=0.0004285715
XR174B a_1047143_1269400# a_1904286_1263400# RPP W=2.4e-06 L=0.0004285715
XR175A a_151400_1269400# a_155000_1269400# RPP W=2.4e-06 L=0.0004285715
XR175B a_155000_1269400# a_1012143_1263400# RPP W=2.4e-06 L=0.0004285715
XR176A a_1043543_1269400# a_1047143_1275400# RPP W=2.4e-06 L=0.0004285715
XR176B a_1047143_1275400# a_1904286_1275400# RPP W=2.4e-06 L=0.0004285715
XR177A a_151400_1269400# a_155000_1275400# RPP W=2.4e-06 L=0.0004285715
XR177B a_155000_1275400# a_1012143_1275400# RPP W=2.4e-06 L=0.0004285715
XR178A a_1043543_1281400# a_1047143_1281400# RPP W=2.4e-06 L=0.0004285715
XR178B a_1047143_1281400# a_1904286_1275400# RPP W=2.4e-06 L=0.0004285715
XR179A a_151400_1281400# a_155000_1281400# RPP W=2.4e-06 L=0.0004285715
XR179B a_155000_1281400# a_1012143_1275400# RPP W=2.4e-06 L=0.0004285715
XR180A a_1043543_1281400# a_1047143_1287400# RPP W=2.4e-06 L=0.0004285715
XR180B a_1047143_1287400# a_1904286_1287400# RPP W=2.4e-06 L=0.0004285715
XR181A a_151400_1281400# a_155000_1287400# RPP W=2.4e-06 L=0.0004285715
XR181B a_155000_1287400# a_1012143_1287400# RPP W=2.4e-06 L=0.0004285715
XR182A a_1043543_1293400# a_1047143_1293400# RPP W=2.4e-06 L=0.0004285715
XR182B a_1047143_1293400# a_1904286_1287400# RPP W=2.4e-06 L=0.0004285715
XR183A a_151400_1293400# a_155000_1293400# RPP W=2.4e-06 L=0.0004285715
XR183B a_155000_1293400# a_1012143_1287400# RPP W=2.4e-06 L=0.0004285715
XR184A a_1043543_1293400# a_1047143_1299400# RPP W=2.4e-06 L=0.0004285715
XR184B a_1047143_1299400# a_1904286_1299400# RPP W=2.4e-06 L=0.0004285715
XR185A a_151400_1293400# a_155000_1299400# RPP W=2.4e-06 L=0.0004285715
XR185B a_155000_1299400# a_1012143_1299400# RPP W=2.4e-06 L=0.0004285715
XR186A a_1043543_1305400# a_1047143_1305400# RPP W=2.4e-06 L=0.0004285715
XR186B a_1047143_1305400# a_1904286_1299400# RPP W=2.4e-06 L=0.0004285715
XR187A a_151400_1305400# a_155000_1305400# RPP W=2.4e-06 L=0.0004285715
XR187B a_155000_1305400# a_1012143_1299400# RPP W=2.4e-06 L=0.0004285715
XR188A a_1043543_1305400# a_1047143_1311400# RPP W=2.4e-06 L=0.0004285715
XR188B a_1047143_1311400# a_1904286_1311400# RPP W=2.4e-06 L=0.0004285715
XR189A a_151400_1305400# a_155000_1311400# RPP W=2.4e-06 L=0.0004285715
XR189B a_155000_1311400# a_1012143_1311400# RPP W=2.4e-06 L=0.0004285715
XR190A a_1043543_1317400# a_1047143_1317400# RPP W=2.4e-06 L=0.0004285715
XR190B a_1047143_1317400# a_1904286_1311400# RPP W=2.4e-06 L=0.0004285715
XR191A a_151400_1317400# a_155000_1317400# RPP W=2.4e-06 L=0.0004285715
XR191B a_155000_1317400# a_1012143_1311400# RPP W=2.4e-06 L=0.0004285715
XR192A a_1043543_1317400# a_1047143_1323400# RPP W=2.4e-06 L=0.0004285715
XR192B a_1047143_1323400# a_1904286_1323400# RPP W=2.4e-06 L=0.0004285715
XR193A a_151400_1317400# a_155000_1323400# RPP W=2.4e-06 L=0.0004285715
XR193B a_155000_1323400# a_1012143_1323400# RPP W=2.4e-06 L=0.0004285715
XR194A a_1043543_1329400# a_1047143_1329400# RPP W=2.4e-06 L=0.0004285715
XR194B a_1047143_1329400# a_1904286_1323400# RPP W=2.4e-06 L=0.0004285715
XR195A a_151400_1329400# a_155000_1329400# RPP W=2.4e-06 L=0.0004285715
XR195B a_155000_1329400# a_1012143_1323400# RPP W=2.4e-06 L=0.0004285715
XR196A a_1043543_1329400# a_1047143_1335400# RPP W=2.4e-06 L=0.0004285715
XR196B a_1047143_1335400# a_1904286_1335400# RPP W=2.4e-06 L=0.0004285715
XR197A a_151400_1329400# a_155000_1335400# RPP W=2.4e-06 L=0.0004285715
XR197B a_155000_1335400# a_1012143_1335400# RPP W=2.4e-06 L=0.0004285715
XR198A a_151400_1341400# a_1047143_1341400# RPP W=2.4e-06 L=0.0004285715
XR198B a_1047143_1341400# a_1904286_1335400# RPP W=2.4e-06 L=0.0004285715
XR199A a_151400_1341400# a_155000_1341400# RPP W=2.4e-06 L=0.0004285715
XR199B a_155000_1341400# a_1012143_1335400# RPP W=2.4e-06 L=0.0004285715
.ends
