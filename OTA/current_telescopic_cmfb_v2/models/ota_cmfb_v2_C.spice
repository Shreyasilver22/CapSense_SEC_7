* NGSPICE file created from ota_telescopic_layout.ext - technology: SCL_CP8D

.subckt ota_telescopic_cmfb_v2 INP INN OUTP OUTM VDD VSS IREF VCM VBN VBP
M1000 VDD OUTM a_166200_473000# VSS N w=20u l=1.6u
+  ad=90.00001p pd=49u as=90.00001p ps=49u
M1001 OUTP a_163000_528900# OUTP OUTP P w=20u l=10u
+  ad=90.00001p pd=49u as=-1.86497n ps=1.305m
M1002 OUTP a_163000_528900# OUTP OUTP P w=20u l=10u
+  ad=90.00001p pd=49u as=-0 ps=0
M1003 a_163000_868700# IREF VSS VSS N w=11.429u l=3.2u
+  ad=51.4305p pd=31.858u as=51.4305p ps=31.858u
M1004 OUTP a_163000_528900# OUTP OUTP P w=20u l=10u
+  ad=90.00001p pd=49u as=-0 ps=0
M1005 VDD a_163000_528900# VDD VDD P w=20u l=10u
+  ad=90.00001p pd=49u as=1.305n ps=0.706m
M1006 a_200200_868700# a_200200_868700# VSS VSS N w=10u l=3.2u
+  ad=45p pd=29u as=45p ps=29u
M1007 a_239000_71400# INN a_166200_71400# VSS N w=15u l=2.4u
+  ad=67.50001p pd=39u as=67.50001p ps=39u
M1008 a_158500_217600# a_163000_528900# VDD VDD P w=40u l=3.2u
+  ad=0.18n pd=89u as=0.18n ps=89u
M1009 OUTM a_163000_528900# OUTM OUTM P w=20u l=10u
+  ad=90.00001p pd=49u as=-1.86497n ps=1.305m
M1010 OUTP a_163000_528900# OUTP OUTP P w=20u l=10u
+  ad=90.00001p pd=49u as=-0 ps=0
M1011 OUTM a_163000_528900# OUTM OUTM P w=20u l=10u
+  ad=90.00001p pd=49u as=-0 ps=0
M1012 OUTM a_163000_528900# OUTM OUTM P w=20u l=10u
+  ad=90.00001p pd=49u as=-0 ps=0
M1013 OUTM a_163000_528900# OUTM OUTM P w=20u l=10u
+  ad=90.00001p pd=49u as=-0 ps=0
M1014 a_274600_868700# a_274600_868700# VSS VSS N w=10u l=3.2u
+  ad=45p pd=29u as=45p ps=29u
M1015 OUTP VBN a_239000_71400# VSS N w=30u l=2.4u
+  ad=0.135n pd=69u as=0.135n ps=69u
M1016 VDD OUTM a_166200_473000# VSS N w=20u l=1.6u
+  ad=90.00001p pd=49u as=90.00001p ps=49u
M1017 VDD OUTM a_166200_473000# VSS N w=20u l=1.6u
+  ad=90.00001p pd=49u as=90.00001p ps=49u
M1018 VDD OUTP a_158500_329400# VSS N w=20u l=1.6u
+  ad=90.00001p pd=49u as=90.00001p ps=49u
M1019 a_163000_916100# a_163000_916100# VDD VDD P w=10u l=3.2u
+  ad=45p pd=29u as=45p ps=29u
M1020 VDD a_163000_528900# VDD VDD P w=20u l=10u
+  ad=90.00001p pd=49u as=0 ps=0
M1021 OUTP a_163000_528900# OUTP OUTP P w=20u l=10u
+  ad=90.00001p pd=49u as=-0 ps=0
M1022 OUTP a_163000_528900# OUTP OUTP P w=20u l=10u
+  ad=90.00001p pd=49u as=-0 ps=0
M1023 VDD VCM a_158500_401200# VSS N w=20u l=1.6u
+  ad=90.00001p pd=49u as=90.00001p ps=49u
M1024 VDD VCM a_158500_401200# VSS N w=20u l=1.6u
+  ad=90.00001p pd=49u as=90.00001p ps=49u
M1025 OUTP a_163000_528900# OUTP OUTP P w=20u l=10u
+  ad=90.00001p pd=49u as=-0 ps=0
M1026 a_166200_473000# IREF VSS VSS N w=20u l=3.2u
+  ad=90.00001p pd=49u as=90.00001p ps=49u
M1027 a_163000_528900# a_200200_868700# VSS VSS N w=10u l=3.2u
+  ad=45p pd=29u as=45p ps=29u
M1028 a_200200_868700# a_161400_1209400# a_166200_870200# VDD P w=5u l=2.4u
+  ad=22.5p pd=19u as=22.5p ps=19u
M1029 a_158500_329400# IREF VSS VSS N w=20u l=3.2u
+  ad=90.00001p pd=49u as=90.00001p ps=49u
M1030 VDD a_163000_528900# VDD VDD P w=20u l=10u
+  ad=90.00001p pd=49u as=0 ps=0
M1031 VDD OUTP a_158500_329400# VSS N w=20u l=1.6u
+  ad=90.00001p pd=49u as=90.00001p ps=49u
M1032 a_163000_916100# a_274600_868700# VSS VSS N w=10u l=3.2u
+  ad=45p pd=29u as=45p ps=29u
M1033 OUTM VBN a_202600_71400# VSS N w=30u l=2.4u
+  ad=0.135n pd=69u as=0.135n ps=69u
M1034 a_158500_329400# IREF VSS VSS N w=20u l=3.2u
+  ad=90.00001p pd=49u as=90.00001p ps=49u
M1035 VDD VCM a_158500_401200# VSS N w=20u l=1.6u
+  ad=90.00001p pd=49u as=90.00001p ps=49u
M1036 VDD VCM a_158500_401200# VSS N w=20u l=1.6u
+  ad=90.00001p pd=49u as=90.00001p ps=49u
M1037 a_166200_473000# IREF VSS VSS N w=20u l=3.2u
+  ad=90.00001p pd=49u as=90.00001p ps=49u
M1038 VDD OUTP a_158500_329400# VSS N w=20u l=1.6u
+  ad=90.00001p pd=49u as=90.00001p ps=49u
M1039 a_166200_71400# IREF VSS VSS N w=80.00001u l=3.2u
+  ad=0.36n pd=0.169m as=0.36n ps=0.169m
M1040 a_158500_401200# IREF VSS VSS N w=20u l=3.2u
+  ad=90.00001p pd=49u as=90.00001p ps=49u
M1041 OUTP VBP a_158500_217600# VDD P w=60u l=2.4u
+  ad=0.27n pd=0.129m as=0.27n ps=0.129m
M1042 OUTM VBP a_202600_217600# VDD P w=60u l=2.4u
+  ad=0.27n pd=0.129m as=0.27n ps=0.129m
M1043 a_163000_868700# a_163000_868700# VDD VDD P w=20u l=3.2u
+  ad=90.00001p pd=49u as=90.00001p ps=49u
M1044 a_166200_870200# a_163000_868700# VDD VDD P w=10u l=3.2u
+  ad=45p pd=29u as=45p ps=29u
M1045 a_202600_217600# a_163000_528900# VDD VDD P w=40u l=3.2u
+  ad=0.18n pd=89u as=0.18n ps=89u
M1046 OUTM a_163000_528900# OUTM OUTM P w=20u l=10u
+  ad=90.00001p pd=49u as=-0 ps=0
M1047 OUTM a_163000_528900# OUTM OUTM P w=20u l=10u
+  ad=90.00001p pd=49u as=-0 ps=0
M1048 a_158500_401200# IREF VSS VSS N w=20u l=3.2u
+  ad=90.00001p pd=49u as=90.00001p ps=49u
M1049 OUTM a_163000_528900# OUTM OUTM P w=20u l=10u
+  ad=90.00001p pd=49u as=-0 ps=0
M1050 OUTM a_163000_528900# OUTM OUTM P w=20u l=10u
+  ad=90.00001p pd=49u as=-0 ps=0
M1051 OUTM a_163000_528900# OUTM OUTM P w=20u l=10u
+  ad=90.00001p pd=49u as=-0 ps=0
M1052 OUTP a_163000_528900# OUTP OUTP P w=20u l=10u
+  ad=90.00001p pd=49u as=-0 ps=0
M1053 IREF IREF VSS VSS N w=20u l=3.2u
+  ad=90.00001p pd=49u as=90.00001p ps=49u
M1054 OUTP a_163000_528900# OUTP OUTP P w=20u l=10u
+  ad=90.00001p pd=49u as=-0 ps=0
M1055 OUTM a_163000_528900# OUTM OUTM P w=20u l=10u
+  ad=90.00001p pd=49u as=-0 ps=0
M1056 OUTP a_163000_528900# OUTP OUTP P w=20u l=10u
+  ad=90.00001p pd=49u as=-0 ps=0
M1057 OUTM a_163000_528900# OUTM OUTM P w=20u l=10u
+  ad=90.00001p pd=49u as=-0 ps=0
M1058 OUTP a_163000_528900# OUTP OUTP P w=20u l=10u
+  ad=90.00001p pd=49u as=-0 ps=0
M1059 a_202600_71400# INP a_166200_71400# VSS N w=15u l=2.4u
+  ad=67.50001p pd=39u as=67.50001p ps=39u
M1060 OUTM a_163000_528900# OUTM OUTM P w=20u l=10u
+  ad=90.00001p pd=49u as=-0 ps=0
M1061 OUTP a_163000_528900# OUTP OUTP P w=20u l=10u
+  ad=90.00001p pd=49u as=-0 ps=0
M1062 a_274600_868700# a_158500_401200# a_166200_870200# VDD P w=5u l=2.4u
+  ad=22.5p pd=19u as=22.5p ps=19u
M1063 a_163000_528900# a_163000_916100# VDD VDD P w=10u l=3.2u
+  ad=45p pd=29u as=45p ps=29u
M1064 VDD OUTM a_166200_473000# VSS N w=20u l=1.6u
+  ad=90.00001p pd=49u as=90.00001p ps=49u
M1065 VDD OUTP a_158500_329400# VSS N w=20u l=1.6u
+  ad=90.00001p pd=49u as=90.00001p ps=49u
M1066 VDD a_163000_528900# VDD VDD P w=20u l=10u
+  ad=90.00001p pd=49u as=0 ps=0
C0 a_161400_1137400# a_165000_1143400# 0.05819f
C1 a_161400_1077400# a_165000_1077400# 0.05819f
C2 a_158500_401200# VDD 5.75039f
C3 a_202600_217600# a_202600_71400# 0.64513f
C4 a_1057142_1191400# a_1057142_1179400# 0
C5 a_165000_1125400# a_593571_1119400# 0.05819f
C6 a_239000_71400# VSS 1.72421f
C7 a_624971_1065400# a_624971_1053400# 0
C8 a_274600_868700# OUTM 1.93539f
C9 a_593571_1167400# a_165000_1167400# 0.05819f
C10 a_161400_1101400# a_165000_1107400# 0.05819f
C11 a_166200_71400# IREF 1.03977f
C12 a_161400_1041400# a_165000_1041400# 0.05819f
C13 a_1057142_1155400# a_1057142_1143400# 0
C14 a_165000_1089400# a_593571_1083400# 0.05819f
C15 a_161400_1209400# a_163000_868700# 1.14736f
C16 a_624971_1029400# a_624971_1017400# 0
C17 a_163000_528900# a_158500_401200# 3.08143f
C18 a_200200_868700# a_274600_868700# 1.46861f
C19 a_163000_868700# a_166200_870200# 1.51542f
C20 OUTM VBN 0.82212f
C21 VDD INP 0.28651f
C22 OUTP VBP 1.95405f
C23 VSS VCM 2.2934f
C24 a_593571_1131400# a_165000_1131400# 0.05819f
C25 a_163000_916100# VSS 2.61092f
C26 a_161400_1065400# a_165000_1071400# 0.05819f
C27 a_161400_1005400# a_165000_1005400# 0.05819f
C28 a_1057142_1119400# a_1057142_1107400# 0
C29 a_202600_71400# INN 0.28651f
C30 a_166200_473000# IREF 2.39477f
C31 a_165000_1053400# a_593571_1047400# 0.05819f
C32 a_624971_993400# a_624971_981400# 0
C33 a_593571_1095400# a_165000_1095400# 0.05819f
C34 a_161400_1029400# a_165000_1035400# 0.05819f
C35 a_158500_329400# VCM 1.43255f
C36 a_1057142_1083400# a_1057142_1071400# 0
C37 a_165000_1017400# a_593571_1011400# 0.05819f
C38 a_202600_217600# VDD 2.75151f
C39 a_166200_71400# a_239000_71400# 0.92537f
C40 a_624971_1185400# a_628571_1185400# 0.05819f
C41 a_161400_1185400# a_161400_1173400# 0
C42 a_593571_1059400# a_165000_1059400# 0.05819f
C43 a_161400_993400# a_165000_999400# 0.05819f
C44 a_158500_401200# OUTM 2.6507f
C45 a_239000_71400# IREF 0.28651f
C46 a_1057142_1047400# a_1057142_1035400# 0
C47 a_165000_981400# a_593571_975400# 0.05819f
C48 a_624971_1149400# a_628571_1149400# 0.05819f
C49 a_161400_1149400# a_161400_1137400# 0
C50 a_161400_1209400# a_274600_868700# 0.3252f
C51 a_593571_1023400# a_165000_1023400# 0.05819f
C52 a_163000_528900# a_202600_217600# 0.65988f
C53 a_200200_868700# a_158500_401200# 0.28651f
C54 a_274600_868700# a_166200_870200# 1.25354f
C55 a_628571_1197400# a_1057142_1191400# 0.05819f
C56 a_163000_868700# VSS 3.1902f
C57 a_1057142_1011400# a_1057142_999400# 0
C58 a_158500_217600# VBP 0.92297f
C59 a_624971_1173400# a_628571_1179400# 0.05819f
C60 a_624971_1113400# a_628571_1113400# 0.05819f
C61 a_161400_1113400# a_161400_1101400# 0
C62 OUTM INP 0.28651f
C63 VDD INN 0.28651f
C64 VSS VBP 3.15161f
C65 IREF VCM 0.59669f
C66 OUTP VBN 0.5356f
C67 a_593571_987400# a_165000_987400# 0.05819f
C68 a_628571_1161400# a_1057142_1155400# 0.05819f
C69 a_166200_473000# VCM 0.28651f
C70 a_1057142_1203400# a_628571_1203400# 0.05819f
C71 a_593571_1203400# a_593571_1191400# 0
C72 a_624971_1137400# a_628571_1143400# 0.05819f
C73 a_624971_1077400# a_628571_1077400# 0.05819f
C74 a_161400_1077400# a_161400_1065400# 0
C75 a_202600_71400# VDD 0.28651f
C76 a_158500_329400# VBP 0.32256f
C77 a_628571_1125400# a_1057142_1119400# 0.05819f
C78 a_202600_217600# OUTM 0.90578f
C79 a_1057142_1167400# a_628571_1167400# 0.05819f
C80 a_593571_1167400# a_593571_1155400# 0
C81 a_624971_1101400# a_628571_1107400# 0.05819f
C82 a_624971_1041400# a_628571_1041400# 0.05819f
C83 a_161400_1041400# a_161400_1029400# 0
C84 a_161400_1209400# a_165000_1209400# 0.05572f
C85 a_158500_401200# OUTP 0.9677f
C86 a_161400_1209400# a_158500_401200# 0.28651f
C87 a_628571_1089400# a_1057142_1083400# 0.05819f
C88 a_166200_870200# a_158500_401200# 0.38238f
C89 a_1057142_1131400# a_628571_1131400# 0.05819f
C90 a_593571_1131400# a_593571_1119400# 0
C91 a_274600_868700# VSS 3.56719f
C92 a_624971_1065400# a_628571_1071400# 0.05819f
C93 a_624971_1005400# a_628571_1005400# 0.05819f
C94 a_161400_1005400# a_161400_993400# 0
C95 a_166200_71400# VBP 0.31018f
C96 a_163000_868700# IREF 0.39173f
C97 a_628571_1053400# a_1057142_1047400# 0.05819f
C98 a_1057142_1095400# a_628571_1095400# 0.05819f
C99 a_593571_1095400# a_593571_1083400# 0
C100 VSS VBN 1.71906f
C101 a_624971_1029400# a_628571_1035400# 0.05819f
C102 OUTP INP 0.28651f
C103 OUTM INN 0.28651f
C104 IREF VBP 1.14604f
C105 a_166200_473000# a_163000_868700# 0.00264f
C106 a_161400_1197400# a_165000_1197400# 0.05819f
C107 a_628571_1017400# a_1057142_1011400# 0.05819f
C108 a_624971_1185400# a_624971_1173400# 0
C109 a_1057142_1059400# a_628571_1059400# 0.05819f
C110 a_593571_1059400# a_593571_1047400# 0
C111 a_624971_993400# a_628571_999400# 0.05819f
C112 a_202600_71400# OUTM 0.70379f
C113 a_161400_1161400# a_165000_1161400# 0.05819f
C114 a_628571_981400# a_1057142_975400# 0.05819f
C115 a_165000_1209400# a_593571_1203400# 0.05819f
C116 a_161400_1209400# a_628571_1209400# 0.05572f
C117 a_202600_217600# OUTP 1.50466f
C118 a_624971_1149400# a_624971_1137400# 0
C119 a_1057142_1023400# a_628571_1023400# 0.05819f
C120 a_593571_1023400# a_593571_1011400# 0
C121 a_163000_528900# VDD 13.8819f
C122 a_161400_1185400# a_165000_1191400# 0.05819f
C123 a_158500_401200# VSS 6.44977f
C124 a_161400_1125400# a_165000_1125400# 0.05819f
C125 a_239000_71400# VBP 0.28651f
C126 a_165000_1173400# a_593571_1167400# 0.05819f
C127 a_624971_1113400# a_624971_1101400# 0
C128 a_274600_868700# IREF 0.32256f
C129 a_1057142_987400# a_628571_987400# 0.05819f
C130 a_593571_987400# a_593571_975400# 0
C131 a_166200_71400# VBN 0.57302f
C132 a_161400_1149400# a_165000_1155400# 0.05819f
C133 a_161400_1089400# a_165000_1089400# 0.05819f
C134 a_158500_329400# a_158500_401200# 0.64909f
C135 a_163000_916100# a_163000_868700# 0.32256f
C136 a_1057142_1203400# a_1057142_1191400# 0
C137 a_165000_1137400# a_593571_1131400# 0.05819f
C138 a_624971_1077400# a_624971_1065400# 0
C139 IREF VBN 0.28783f
C140 OUTP INN 0.28651f
C141 VSS INP 0.28651f
C142 a_593571_1179400# a_165000_1179400# 0.05819f
C143 a_161400_1113400# a_165000_1119400# 0.05819f
C144 a_161400_1053400# a_165000_1053400# 0.05819f
C145 VDD OUTM 5.43802f
C146 a_1057142_1167400# a_1057142_1155400# 0
C147 a_165000_1101400# a_593571_1095400# 0.05819f
C148 a_624971_1041400# a_624971_1029400# 0
C149 a_161400_1209400# a_161400_1197400# 0.00328f
C150 a_202600_71400# OUTP 0.28651f
C151 a_593571_1143400# a_165000_1143400# 0.05819f
C152 a_161400_1077400# a_165000_1083400# 0.05819f
C153 a_161400_1017400# a_165000_1017400# 0.05819f
C154 a_158500_217600# a_202600_217600# 0.28651f
C155 a_200200_868700# VDD 2.62168f
C156 a_1057142_1131400# a_1057142_1119400# 0
C157 a_202600_217600# VSS 3.36794f
C158 a_165000_1065400# a_593571_1059400# 0.05819f
C159 a_624971_1005400# a_624971_993400# 0
C160 a_163000_528900# OUTM 19.2685f
C161 a_593571_1107400# a_165000_1107400# 0.05819f
C162 a_158500_401200# IREF 3.18412f
C163 a_161400_1041400# a_165000_1047400# 0.05819f
C164 a_161400_981400# a_165000_981400# 0.05819f
C165 a_239000_71400# VBN 0.91104f
C166 a_1057142_1095400# a_1057142_1083400# 0
C167 a_165000_1029400# a_593571_1023400# 0.05819f
C168 a_163000_916100# a_274600_868700# 1.05056f
C169 a_163000_528900# a_200200_868700# 1.22891f
C170 a_158500_329400# a_202600_217600# 0.32256f
C171 a_166200_473000# a_158500_401200# 1.00264f
C172 a_624971_1197400# a_628571_1197400# 0.05819f
C173 a_161400_1197400# a_161400_1185400# 0
C174 a_166200_71400# INP 0.47348f
C175 a_593571_1071400# a_165000_1071400# 0.05819f
C176 a_161400_1005400# a_165000_1011400# 0.05819f
C177 a_1057142_1059400# a_1057142_1047400# 0
C178 a_165000_993400# a_593571_987400# 0.05819f
C179 VSS INN 0.28651f
C180 IREF INP 0.28651f
C181 a_624971_1161400# a_628571_1161400# 0.05819f
C182 a_161400_1161400# a_161400_1149400# 0
C183 a_593571_1035400# a_165000_1035400# 0.05819f
C184 a_158500_329400# a_165000_975400# 0.05572f
C185 a_161400_1209400# a_624971_1197400# 0.00328f
C186 a_628571_1209400# a_1057142_1203400# 0.05819f
C187 VDD OUTP 7.38011f
C188 a_161400_1209400# VDD 1.79117f
C189 a_1057142_1023400# a_1057142_1011400# 0
C190 a_202600_217600# a_166200_71400# 0.9677f
C191 a_166200_870200# VDD 2.64504f
C192 a_624971_1185400# a_628571_1191400# 0.05819f
C193 a_202600_71400# VSS 1.72421f
C194 a_624971_1125400# a_628571_1125400# 0.05819f
C195 a_161400_1125400# a_161400_1113400# 0
C196 a_593571_999400# a_165000_999400# 0.05819f
C197 a_200200_868700# OUTM 1.71906f
C198 a_628571_1173400# a_1057142_1167400# 0.05819f
C199 a_202600_217600# IREF 1.1821f
C200 a_1057142_987400# a_1057142_975400# 0
C201 a_163000_528900# OUTP 20.4286f
C202 a_624971_1149400# a_628571_1155400# 0.05819f
C203 a_161400_1209400# a_163000_528900# 1.1821f
C204 a_624971_1089400# a_628571_1089400# 0.05819f
C205 a_161400_1089400# a_161400_1077400# 0
C206 a_158500_401200# VCM 2.10466f
C207 a_163000_528900# a_166200_870200# 1.14604f
C208 a_163000_868700# a_274600_868700# 1.54072f
C209 a_239000_71400# INP 0.28651f
C210 a_628571_1137400# a_1057142_1131400# 0.05819f
C211 a_1057142_1179400# a_628571_1179400# 0.05819f
C212 a_593571_1179400# a_593571_1167400# 0
C213 a_624971_1113400# a_628571_1119400# 0.05819f
C214 a_166200_71400# INN 0.47348f
C215 a_624971_1053400# a_628571_1053400# 0.05819f
C216 a_161400_1053400# a_161400_1041400# 0
C217 a_628571_1101400# a_1057142_1095400# 0.05819f
C218 IREF INN 0.28651f
C219 VBP VBN 0.57302f
C220 a_1057142_1143400# a_628571_1143400# 0.05819f
C221 a_593571_1143400# a_593571_1131400# 0
C222 a_624971_1077400# a_628571_1083400# 0.05819f
C223 a_624971_1017400# a_628571_1017400# 0.05819f
C224 a_161400_1017400# a_161400_1005400# 0
C225 a_158500_217600# VDD 2.14243f
C226 a_202600_217600# a_239000_71400# 0.64513f
C227 a_166200_71400# a_202600_71400# 0.92537f
C228 OUTM OUTP 4.34692f
C229 VDD VSS 11.5455f
C230 a_628571_1065400# a_1057142_1059400# 0.05819f
C231 a_161400_1209400# OUTM 1.71906f
C232 a_166200_870200# OUTM 1.71906f
C233 a_1057142_1107400# a_628571_1107400# 0.05819f
C234 a_593571_1107400# a_593571_1095400# 0
C235 a_624971_1041400# a_628571_1047400# 0.05819f
C236 a_202600_71400# IREF 0.28651f
C237 a_624971_981400# a_628571_981400# 0.05819f
C238 a_161400_981400# a_158500_329400# 0.00328f
C239 a_161400_1209400# a_200200_868700# 0.66623f
C240 a_628571_1029400# a_1057142_1023400# 0.05819f
C241 a_163000_528900# a_158500_217600# 0.94639f
C242 a_163000_868700# a_158500_401200# 0.28651f
C243 a_200200_868700# a_166200_870200# 1.4456f
C244 a_158500_329400# VDD 7.75596f
C245 a_624971_1197400# a_624971_1185400# 0
C246 a_163000_528900# VSS 7.80223f
C247 a_1057142_1071400# a_628571_1071400# 0.05819f
C248 a_593571_1071400# a_593571_1059400# 0
C249 a_624971_1005400# a_628571_1011400# 0.05819f
C250 a_161400_1173400# a_165000_1173400# 0.05819f
C251 a_239000_71400# INN 0.418f
C252 a_628571_993400# a_1057142_987400# 0.05819f
C253 a_624971_1161400# a_624971_1149400# 0
C254 a_1057142_1035400# a_628571_1035400# 0.05819f
C255 a_593571_1035400# a_593571_1023400# 0
C256 a_166200_473000# a_628571_975400# 0.05572f
C257 a_158500_329400# a_163000_528900# 3.29665f
C258 a_161400_1197400# a_165000_1203400# 0.05819f
C259 a_161400_1137400# a_165000_1137400# 0.05819f
C260 a_166200_71400# VDD 0.28651f
C261 a_202600_71400# a_239000_71400# 0.57302f
C262 a_165000_1185400# a_593571_1179400# 0.05819f
C263 a_624971_1125400# a_624971_1113400# 0
C264 VBP INP 0.28651f
C265 a_1057142_999400# a_628571_999400# 0.05819f
C266 a_593571_999400# a_593571_987400# 0
C267 a_161400_1161400# a_165000_1167400# 0.05819f
C268 a_161400_1101400# a_165000_1101400# 0.05819f
C269 OUTM VSS 4.74013f
C270 VDD IREF 8.14038f
C271 a_165000_1149400# a_593571_1143400# 0.05819f
C272 a_161400_1209400# a_166200_870200# 0.42971f
C273 a_624971_1089400# a_624971_1077400# 0
C274 a_274600_868700# a_158500_401200# 0.35605f
C275 a_166200_473000# VDD 6.00084f
C276 a_593571_1191400# a_165000_1191400# 0.05819f
C277 a_161400_1125400# a_165000_1131400# 0.05819f
C278 a_200200_868700# VSS 3.49508f
C279 a_161400_1065400# a_165000_1065400# 0.05819f
C280 a_202600_217600# VBP 1.53205f
C281 a_158500_329400# OUTM 2.36419f
C282 a_1057142_1179400# a_1057142_1167400# 0
C283 a_165000_1113400# a_593571_1107400# 0.05819f
C284 a_163000_528900# IREF 2.8651f
C285 a_624971_1053400# a_624971_1041400# 0
C286 a_593571_1155400# a_165000_1155400# 0.05819f
C287 a_161400_1089400# a_165000_1095400# 0.05819f
C288 a_161400_1029400# a_165000_1029400# 0.05819f
C289 a_166200_473000# a_163000_528900# 3.12013f
C290 a_1057142_1143400# a_1057142_1131400# 0
C291 a_165000_1077400# a_593571_1071400# 0.05819f
C292 a_624971_1017400# a_624971_1005400# 0
C293 a_239000_71400# VDD 0.28651f
C294 a_593571_1119400# a_165000_1119400# 0.05819f
C295 a_161400_1053400# a_165000_1059400# 0.05819f
C296 a_161400_993400# a_165000_993400# 0.05819f
C297 a_166200_71400# OUTM 0.57302f
C298 a_1057142_1107400# a_1057142_1095400# 0
C299 VBP INN 0.28651f
C300 VBN INP 0.28651f
C301 a_165000_1041400# a_593571_1035400# 0.05819f
C302 a_624971_981400# a_166200_473000# 0.00328f
C303 a_158500_217600# OUTP 1.12018f
C304 a_593571_1083400# a_165000_1083400# 0.05819f
C305 a_161400_1017400# a_165000_1023400# 0.05819f
C306 OUTM IREF 3.58234f
C307 OUTP VSS 3.37309f
C308 VDD VCM 1.70853f
C309 a_163000_916100# VDD 2.60143f
C310 a_161400_1209400# VSS 0.85953f
C311 a_166200_870200# VSS 3.15161f
C312 a_1057142_1071400# a_1057142_1059400# 0
C313 a_165000_1005400# a_593571_999400# 0.05819f
C314 a_202600_71400# VBP 0.28783f
C315 a_166200_473000# OUTM 3.0363f
C316 a_624971_1173400# a_628571_1173400# 0.05819f
C317 a_161400_1173400# a_161400_1161400# 0
C318 a_593571_1047400# a_165000_1047400# 0.05819f
C319 a_200200_868700# IREF 0.28651f
C320 a_161400_981400# a_165000_987400# 0.05819f
C321 a_202600_217600# VBN 0.64513f
C322 a_158500_329400# OUTP 3.64537f
C323 a_161400_1209400# a_158500_329400# 0.33832f
C324 a_1057142_1035400# a_1057142_1023400# 0
C325 a_163000_528900# VCM 0.32256f
C326 a_163000_916100# a_163000_528900# 1.01451f
C327 a_624971_1197400# a_628571_1203400# 0.05819f
C328 a_624971_1137400# a_628571_1137400# 0.05819f
C329 a_161400_1137400# a_161400_1125400# 0
C330 a_593571_1011400# a_165000_1011400# 0.05819f
C331 a_628571_1185400# a_1057142_1179400# 0.05819f
C332 a_1057142_999400# a_1057142_987400# 0
C333 a_239000_71400# OUTM 0.57302f
C334 a_624971_1161400# a_628571_1167400# 0.05819f
C335 a_624971_1101400# a_628571_1101400# 0.05819f
C336 a_161400_1101400# a_161400_1089400# 0
C337 a_593571_975400# a_165000_975400# 0.05819f
C338 a_166200_71400# OUTP 0.28651f
C339 a_628571_1149400# a_1057142_1143400# 0.05819f
C340 VBN INN 0.28651f
C341 a_163000_868700# VDD 3.10699f
C342 a_1057142_1191400# a_628571_1191400# 0.05819f
C343 a_593571_1191400# a_593571_1179400# 0
C344 a_624971_1125400# a_628571_1131400# 0.05819f
C345 a_158500_217600# VSS 1.14604f
C346 a_624971_1065400# a_628571_1065400# 0.05819f
C347 a_161400_1065400# a_161400_1053400# 0
C348 VDD VBP 2.57859f
C349 OUTP IREF 2.8025f
C350 a_161400_1209400# IREF 0.28651f
C351 a_628571_1113400# a_1057142_1107400# 0.05819f
C352 a_166200_870200# IREF 0.28651f
C353 a_202600_71400# VBN 0.91104f
C354 a_166200_473000# OUTP 1.61283f
C355 a_1057142_1155400# a_628571_1155400# 0.05819f
C356 a_593571_1155400# a_593571_1143400# 0
C357 a_161400_1209400# a_166200_473000# 0.33832f
C358 a_624971_1089400# a_628571_1095400# 0.05819f
C359 a_624971_1029400# a_628571_1029400# 0.05819f
C360 a_161400_1029400# a_161400_1017400# 0
C361 a_158500_329400# a_158500_217600# 0.64513f
C362 a_163000_528900# a_163000_868700# 1.14604f
C363 a_163000_916100# a_200200_868700# 0.9677f
C364 a_202600_217600# INP 0.32256f
C365 a_158500_329400# VSS 6.87664f
C366 a_628571_1077400# a_1057142_1071400# 0.05819f
C367 a_163000_528900# VBP 0.28651f
C368 a_1057142_1119400# a_628571_1119400# 0.05819f
C369 a_593571_1119400# a_593571_1107400# 0
C370 a_624971_1053400# a_628571_1059400# 0.05819f
C371 a_624971_993400# a_628571_993400# 0.05819f
C372 a_161400_993400# a_161400_981400# 0
C373 a_628571_1041400# a_1057142_1035400# 0.05819f
C374 a_239000_71400# OUTP 0.41728f
C375 a_1057142_1083400# a_628571_1083400# 0.05819f
C376 a_593571_1083400# a_593571_1071400# 0
C377 a_624971_1017400# a_628571_1023400# 0.05819f
C378 a_274600_868700# VDD 2.7659f
C379 a_161400_1185400# a_165000_1185400# 0.05819f
C380 a_166200_71400# VSS 1.99514f
C381 a_628571_1005400# a_1057142_999400# 0.05819f
C382 INP INN 0.28651f
C383 a_163000_868700# OUTM 1.71906f
C384 a_624971_1173400# a_624971_1161400# 0
C385 a_158500_217600# IREF 0.57302f
C386 a_1057142_1047400# a_628571_1047400# 0.05819f
C387 a_593571_1047400# a_593571_1035400# 0
C388 a_624971_981400# a_628571_987400# 0.05819f
C389 VSS IREF 12.6008f
C390 OUTM VBP 1.05733f
C391 VDD VBN 0.28651f
C392 a_161400_1149400# a_165000_1149400# 0.05819f
C393 a_163000_528900# a_274600_868700# 1.21815f
C394 a_163000_916100# a_166200_870200# 0.32256f
C395 a_163000_868700# a_200200_868700# 1.45622f
C396 a_165000_1197400# a_593571_1191400# 0.05819f
C397 a_624971_1137400# a_624971_1125400# 0
C398 a_202600_71400# INP 0.418f
C399 a_166200_473000# VSS 5.5162f
C400 a_1057142_1011400# a_628571_1011400# 0.05819f
C401 a_593571_1011400# a_593571_999400# 0
C402 a_161400_1173400# a_165000_1179400# 0.05819f
C403 a_161400_1113400# a_165000_1113400# 0.05819f
C404 a_202600_217600# INN 0.32256f
C405 a_158500_329400# IREF 2.46688f
C406 a_165000_1161400# a_593571_1155400# 0.05819f
C407 a_624971_1101400# a_624971_1089400# 0
C408 a_1057142_975400# a_628571_975400# 0.05819f
C409 a_158500_329400# a_166200_473000# 1.03869f
C410 a_593571_1203400# a_165000_1203400# 0.05819f
C411 INN 0 40.6609f
C412 INP 0 52.2652f
C413 VBN 0 47.9744f
C414 VBP 0 95.1364f
C415 VCM 0 60.756f
C416 IREF 0 0.32231p
C417 VSS 0 0.49783p
C418 OUTP 0 0.49053p
C419 OUTM 0 0.45422p
C420 VDD 0 0.57909p
C421 a_239000_71400# 0 24.9066f ; **FLOATING
C422 a_202600_71400# 0 26.7387f ; **FLOATING
C423 a_166200_71400# 0 34.9794f ; **FLOATING
C424 a_202600_217600# 0 71.3632f ; **FLOATING
C425 a_158500_217600# 0 27.364f ; **FLOATING
C426 a_158500_401200# 0 0.13874p ; **FLOATING
C427 a_166200_870200# 0 49.2058f ; **FLOATING
C428 a_274600_868700# 0 69.6143f ; **FLOATING
C429 a_200200_868700# 0 71.0994f ; **FLOATING
C430 a_163000_868700# 0 77.3224f ; **FLOATING
C431 a_163000_528900# 0 0.72663p ; **FLOATING
C432 a_163000_916100# 0 54.6626f ; **FLOATING
C433 a_628571_975400# 0 0.13486p ; **FLOATING
C434 a_166200_473000# 0 0.20511p ; **FLOATING
C435 a_165000_975400# 0 0.13486p ; **FLOATING
C436 a_158500_329400# 0 0.17901p ; **FLOATING
C437 a_1057142_975400# 0 3.33625f
C438 a_628571_981400# 0 0.13292p ; **FLOATING
C439 a_593571_975400# 0 3.33625f
C440 a_165000_981400# 0 0.13292p ; **FLOATING
C441 a_628571_987400# 0 0.13292p ; **FLOATING
C442 a_624971_981400# 0 3.29428f ; **FLOATING
C443 a_165000_987400# 0 0.13292p ; **FLOATING
C444 a_161400_981400# 0 3.29428f ; **FLOATING
C445 a_1057142_987400# 0 3.29428f
C446 a_628571_993400# 0 0.13292p ; **FLOATING
C447 a_593571_987400# 0 3.29428f
C448 a_165000_993400# 0 0.13292p ; **FLOATING
C449 a_628571_999400# 0 0.13292p ; **FLOATING
C450 a_624971_993400# 0 3.29428f ; **FLOATING
C451 a_165000_999400# 0 0.13292p ; **FLOATING
C452 a_161400_993400# 0 3.29428f ; **FLOATING
C453 a_1057142_999400# 0 3.29428f
C454 a_628571_1005400# 0 0.13292p ; **FLOATING
C455 a_593571_999400# 0 3.29428f
C456 a_165000_1005400# 0 0.13292p ; **FLOATING
C457 a_628571_1011400# 0 0.13292p ; **FLOATING
C458 a_624971_1005400# 0 3.29428f ; **FLOATING
C459 a_165000_1011400# 0 0.13292p ; **FLOATING
C460 a_161400_1005400# 0 3.29428f ; **FLOATING
C461 a_1057142_1011400# 0 3.29428f
C462 a_628571_1017400# 0 0.13292p ; **FLOATING
C463 a_593571_1011400# 0 3.29428f
C464 a_165000_1017400# 0 0.13292p ; **FLOATING
C465 a_628571_1023400# 0 0.13292p ; **FLOATING
C466 a_624971_1017400# 0 3.29428f ; **FLOATING
C467 a_165000_1023400# 0 0.13292p ; **FLOATING
C468 a_161400_1017400# 0 3.29428f ; **FLOATING
C469 a_1057142_1023400# 0 3.29428f
C470 a_628571_1029400# 0 0.13292p ; **FLOATING
C471 a_593571_1023400# 0 3.29428f
C472 a_165000_1029400# 0 0.13292p ; **FLOATING
C473 a_628571_1035400# 0 0.13292p ; **FLOATING
C474 a_624971_1029400# 0 3.29428f ; **FLOATING
C475 a_165000_1035400# 0 0.13292p ; **FLOATING
C476 a_161400_1029400# 0 3.29428f ; **FLOATING
C477 a_1057142_1035400# 0 3.29428f
C478 a_628571_1041400# 0 0.13292p ; **FLOATING
C479 a_593571_1035400# 0 3.29428f
C480 a_165000_1041400# 0 0.13292p ; **FLOATING
C481 a_628571_1047400# 0 0.13292p ; **FLOATING
C482 a_624971_1041400# 0 3.29428f ; **FLOATING
C483 a_165000_1047400# 0 0.13292p ; **FLOATING
C484 a_161400_1041400# 0 3.29428f ; **FLOATING
C485 a_1057142_1047400# 0 3.29428f
C486 a_628571_1053400# 0 0.13292p ; **FLOATING
C487 a_593571_1047400# 0 3.29428f
C488 a_165000_1053400# 0 0.13292p ; **FLOATING
C489 a_628571_1059400# 0 0.13292p ; **FLOATING
C490 a_624971_1053400# 0 3.29428f ; **FLOATING
C491 a_165000_1059400# 0 0.13292p ; **FLOATING
C492 a_161400_1053400# 0 3.29428f ; **FLOATING
C493 a_1057142_1059400# 0 3.29428f
C494 a_628571_1065400# 0 0.13292p ; **FLOATING
C495 a_593571_1059400# 0 3.29428f
C496 a_165000_1065400# 0 0.13292p ; **FLOATING
C497 a_628571_1071400# 0 0.13292p ; **FLOATING
C498 a_624971_1065400# 0 3.29428f ; **FLOATING
C499 a_165000_1071400# 0 0.13292p ; **FLOATING
C500 a_161400_1065400# 0 3.29428f ; **FLOATING
C501 a_1057142_1071400# 0 3.29428f
C502 a_628571_1077400# 0 0.13292p ; **FLOATING
C503 a_593571_1071400# 0 3.29428f
C504 a_165000_1077400# 0 0.13292p ; **FLOATING
C505 a_628571_1083400# 0 0.13292p ; **FLOATING
C506 a_624971_1077400# 0 3.29428f ; **FLOATING
C507 a_165000_1083400# 0 0.13292p ; **FLOATING
C508 a_161400_1077400# 0 3.29428f ; **FLOATING
C509 a_1057142_1083400# 0 3.29428f
C510 a_628571_1089400# 0 0.13292p ; **FLOATING
C511 a_593571_1083400# 0 3.29428f
C512 a_165000_1089400# 0 0.13292p ; **FLOATING
C513 a_628571_1095400# 0 0.13292p ; **FLOATING
C514 a_624971_1089400# 0 3.29428f ; **FLOATING
C515 a_165000_1095400# 0 0.13292p ; **FLOATING
C516 a_161400_1089400# 0 3.29428f ; **FLOATING
C517 a_1057142_1095400# 0 3.29428f
C518 a_628571_1101400# 0 0.13292p ; **FLOATING
C519 a_593571_1095400# 0 3.29428f
C520 a_165000_1101400# 0 0.13292p ; **FLOATING
C521 a_628571_1107400# 0 0.13292p ; **FLOATING
C522 a_624971_1101400# 0 3.29428f ; **FLOATING
C523 a_165000_1107400# 0 0.13292p ; **FLOATING
C524 a_161400_1101400# 0 3.29428f ; **FLOATING
C525 a_1057142_1107400# 0 3.29428f
C526 a_628571_1113400# 0 0.13292p ; **FLOATING
C527 a_593571_1107400# 0 3.29428f
C528 a_165000_1113400# 0 0.13292p ; **FLOATING
C529 a_628571_1119400# 0 0.13292p ; **FLOATING
C530 a_624971_1113400# 0 3.29428f ; **FLOATING
C531 a_165000_1119400# 0 0.13292p ; **FLOATING
C532 a_161400_1113400# 0 3.29428f ; **FLOATING
C533 a_1057142_1119400# 0 3.29428f
C534 a_628571_1125400# 0 0.13292p ; **FLOATING
C535 a_593571_1119400# 0 3.29428f
C536 a_165000_1125400# 0 0.13292p ; **FLOATING
C537 a_628571_1131400# 0 0.13292p ; **FLOATING
C538 a_624971_1125400# 0 3.29428f ; **FLOATING
C539 a_165000_1131400# 0 0.13292p ; **FLOATING
C540 a_161400_1125400# 0 3.29428f ; **FLOATING
C541 a_1057142_1131400# 0 3.29428f
C542 a_628571_1137400# 0 0.13292p ; **FLOATING
C543 a_593571_1131400# 0 3.29428f
C544 a_165000_1137400# 0 0.13292p ; **FLOATING
C545 a_628571_1143400# 0 0.13292p ; **FLOATING
C546 a_624971_1137400# 0 3.29428f ; **FLOATING
C547 a_165000_1143400# 0 0.13292p ; **FLOATING
C548 a_161400_1137400# 0 3.29428f ; **FLOATING
C549 a_1057142_1143400# 0 3.29428f
C550 a_628571_1149400# 0 0.13292p ; **FLOATING
C551 a_593571_1143400# 0 3.29428f
C552 a_165000_1149400# 0 0.13292p ; **FLOATING
C553 a_628571_1155400# 0 0.13292p ; **FLOATING
C554 a_624971_1149400# 0 3.29428f ; **FLOATING
C555 a_165000_1155400# 0 0.13292p ; **FLOATING
C556 a_161400_1149400# 0 3.29428f ; **FLOATING
C557 a_1057142_1155400# 0 3.29428f
C558 a_628571_1161400# 0 0.13292p ; **FLOATING
C559 a_593571_1155400# 0 3.29428f
C560 a_165000_1161400# 0 0.13292p ; **FLOATING
C561 a_628571_1167400# 0 0.13292p ; **FLOATING
C562 a_624971_1161400# 0 3.29428f ; **FLOATING
C563 a_165000_1167400# 0 0.13292p ; **FLOATING
C564 a_161400_1161400# 0 3.29428f ; **FLOATING
C565 a_1057142_1167400# 0 3.29428f
C566 a_628571_1173400# 0 0.13292p ; **FLOATING
C567 a_593571_1167400# 0 3.29428f
C568 a_165000_1173400# 0 0.13292p ; **FLOATING
C569 a_628571_1179400# 0 0.13292p ; **FLOATING
C570 a_624971_1173400# 0 3.29428f ; **FLOATING
C571 a_165000_1179400# 0 0.13292p ; **FLOATING
C572 a_161400_1173400# 0 3.29428f ; **FLOATING
C573 a_1057142_1179400# 0 3.29428f
C574 a_628571_1185400# 0 0.13292p ; **FLOATING
C575 a_593571_1179400# 0 3.29428f
C576 a_165000_1185400# 0 0.13292p ; **FLOATING
C577 a_628571_1191400# 0 0.13292p ; **FLOATING
C578 a_624971_1185400# 0 3.29428f ; **FLOATING
C579 a_165000_1191400# 0 0.13292p ; **FLOATING
C580 a_161400_1185400# 0 3.29428f ; **FLOATING
C581 a_1057142_1191400# 0 3.29428f
C582 a_628571_1197400# 0 0.13292p ; **FLOATING
C583 a_593571_1191400# 0 3.29428f
C584 a_165000_1197400# 0 0.13292p ; **FLOATING
C585 a_628571_1203400# 0 0.13292p ; **FLOATING
C586 a_624971_1197400# 0 3.29428f ; **FLOATING
C587 a_165000_1203400# 0 0.13292p ; **FLOATING
C588 a_161400_1197400# 0 3.29428f ; **FLOATING
C589 a_1057142_1203400# 0 3.33625f
C590 a_628571_1209400# 0 0.13486p ; **FLOATING
C591 a_593571_1203400# 0 3.33625f
C592 a_165000_1209400# 0 0.13486p ; **FLOATING
C593 a_161400_1209400# 0 0.16107p ; **FLOATING
XR0A a_166200_473000# a_628571_975400# RPP W=2.4e-06 L=0.0002142855
XR0B a_628571_975400# a_1057142_975400# RPP W=2.4e-06 L=0.0002142855
XR1A a_158500_329400# a_165000_975400# RPP W=2.4e-06 L=0.0002142855
XR1B a_165000_975400# a_593571_975400# RPP W=2.4e-06 L=0.0002142855
XR2A a_624971_981400# a_628571_981400# RPP W=2.4e-06 L=0.0002142855
XR2B a_628571_981400# a_1057142_975400# RPP W=2.4e-06 L=0.0002142855
XR3A a_161400_981400# a_165000_981400# RPP W=2.4e-06 L=0.0002142855
XR3B a_165000_981400# a_593571_975400# RPP W=2.4e-06 L=0.0002142855
XR4A a_624971_981400# a_628571_987400# RPP W=2.4e-06 L=0.0002142855
XR4B a_628571_987400# a_1057142_987400# RPP W=2.4e-06 L=0.0002142855
XR5A a_161400_981400# a_165000_987400# RPP W=2.4e-06 L=0.0002142855
XR5B a_165000_987400# a_593571_987400# RPP W=2.4e-06 L=0.0002142855
XR6A a_624971_993400# a_628571_993400# RPP W=2.4e-06 L=0.0002142855
XR6B a_628571_993400# a_1057142_987400# RPP W=2.4e-06 L=0.0002142855
XR7A a_161400_993400# a_165000_993400# RPP W=2.4e-06 L=0.0002142855
XR7B a_165000_993400# a_593571_987400# RPP W=2.4e-06 L=0.0002142855
XR8A a_624971_993400# a_628571_999400# RPP W=2.4e-06 L=0.0002142855
XR8B a_628571_999400# a_1057142_999400# RPP W=2.4e-06 L=0.0002142855
XR9A a_161400_993400# a_165000_999400# RPP W=2.4e-06 L=0.0002142855
XR9B a_165000_999400# a_593571_999400# RPP W=2.4e-06 L=0.0002142855
XR10A a_624971_1005400# a_628571_1005400# RPP W=2.4e-06 L=0.0002142855
XR10B a_628571_1005400# a_1057142_999400# RPP W=2.4e-06 L=0.0002142855
XR11A a_161400_1005400# a_165000_1005400# RPP W=2.4e-06 L=0.0002142855
XR11B a_165000_1005400# a_593571_999400# RPP W=2.4e-06 L=0.0002142855
XR12A a_624971_1005400# a_628571_1011400# RPP W=2.4e-06 L=0.0002142855
XR12B a_628571_1011400# a_1057142_1011400# RPP W=2.4e-06 L=0.0002142855
XR13A a_161400_1005400# a_165000_1011400# RPP W=2.4e-06 L=0.0002142855
XR13B a_165000_1011400# a_593571_1011400# RPP W=2.4e-06 L=0.0002142855
XR14A a_624971_1017400# a_628571_1017400# RPP W=2.4e-06 L=0.0002142855
XR14B a_628571_1017400# a_1057142_1011400# RPP W=2.4e-06 L=0.0002142855
XR15A a_161400_1017400# a_165000_1017400# RPP W=2.4e-06 L=0.0002142855
XR15B a_165000_1017400# a_593571_1011400# RPP W=2.4e-06 L=0.0002142855
XR16A a_624971_1017400# a_628571_1023400# RPP W=2.4e-06 L=0.0002142855
XR16B a_628571_1023400# a_1057142_1023400# RPP W=2.4e-06 L=0.0002142855
XR17A a_161400_1017400# a_165000_1023400# RPP W=2.4e-06 L=0.0002142855
XR17B a_165000_1023400# a_593571_1023400# RPP W=2.4e-06 L=0.0002142855
XR18A a_624971_1029400# a_628571_1029400# RPP W=2.4e-06 L=0.0002142855
XR18B a_628571_1029400# a_1057142_1023400# RPP W=2.4e-06 L=0.0002142855
XR19A a_161400_1029400# a_165000_1029400# RPP W=2.4e-06 L=0.0002142855
XR19B a_165000_1029400# a_593571_1023400# RPP W=2.4e-06 L=0.0002142855
XR20A a_624971_1029400# a_628571_1035400# RPP W=2.4e-06 L=0.0002142855
XR20B a_628571_1035400# a_1057142_1035400# RPP W=2.4e-06 L=0.0002142855
XR21A a_161400_1029400# a_165000_1035400# RPP W=2.4e-06 L=0.0002142855
XR21B a_165000_1035400# a_593571_1035400# RPP W=2.4e-06 L=0.0002142855
XR22A a_624971_1041400# a_628571_1041400# RPP W=2.4e-06 L=0.0002142855
XR22B a_628571_1041400# a_1057142_1035400# RPP W=2.4e-06 L=0.0002142855
XR23A a_161400_1041400# a_165000_1041400# RPP W=2.4e-06 L=0.0002142855
XR23B a_165000_1041400# a_593571_1035400# RPP W=2.4e-06 L=0.0002142855
XR24A a_624971_1041400# a_628571_1047400# RPP W=2.4e-06 L=0.0002142855
XR24B a_628571_1047400# a_1057142_1047400# RPP W=2.4e-06 L=0.0002142855
XR25A a_161400_1041400# a_165000_1047400# RPP W=2.4e-06 L=0.0002142855
XR25B a_165000_1047400# a_593571_1047400# RPP W=2.4e-06 L=0.0002142855
XR26A a_624971_1053400# a_628571_1053400# RPP W=2.4e-06 L=0.0002142855
XR26B a_628571_1053400# a_1057142_1047400# RPP W=2.4e-06 L=0.0002142855
XR27A a_161400_1053400# a_165000_1053400# RPP W=2.4e-06 L=0.0002142855
XR27B a_165000_1053400# a_593571_1047400# RPP W=2.4e-06 L=0.0002142855
XR28A a_624971_1053400# a_628571_1059400# RPP W=2.4e-06 L=0.0002142855
XR28B a_628571_1059400# a_1057142_1059400# RPP W=2.4e-06 L=0.0002142855
XR29A a_161400_1053400# a_165000_1059400# RPP W=2.4e-06 L=0.0002142855
XR29B a_165000_1059400# a_593571_1059400# RPP W=2.4e-06 L=0.0002142855
XR30A a_624971_1065400# a_628571_1065400# RPP W=2.4e-06 L=0.0002142855
XR30B a_628571_1065400# a_1057142_1059400# RPP W=2.4e-06 L=0.0002142855
XR31A a_161400_1065400# a_165000_1065400# RPP W=2.4e-06 L=0.0002142855
XR31B a_165000_1065400# a_593571_1059400# RPP W=2.4e-06 L=0.0002142855
XR32A a_624971_1065400# a_628571_1071400# RPP W=2.4e-06 L=0.0002142855
XR32B a_628571_1071400# a_1057142_1071400# RPP W=2.4e-06 L=0.0002142855
XR33A a_161400_1065400# a_165000_1071400# RPP W=2.4e-06 L=0.0002142855
XR33B a_165000_1071400# a_593571_1071400# RPP W=2.4e-06 L=0.0002142855
XR34A a_624971_1077400# a_628571_1077400# RPP W=2.4e-06 L=0.0002142855
XR34B a_628571_1077400# a_1057142_1071400# RPP W=2.4e-06 L=0.0002142855
XR35A a_161400_1077400# a_165000_1077400# RPP W=2.4e-06 L=0.0002142855
XR35B a_165000_1077400# a_593571_1071400# RPP W=2.4e-06 L=0.0002142855
XR36A a_624971_1077400# a_628571_1083400# RPP W=2.4e-06 L=0.0002142855
XR36B a_628571_1083400# a_1057142_1083400# RPP W=2.4e-06 L=0.0002142855
XR37A a_161400_1077400# a_165000_1083400# RPP W=2.4e-06 L=0.0002142855
XR37B a_165000_1083400# a_593571_1083400# RPP W=2.4e-06 L=0.0002142855
XR38A a_624971_1089400# a_628571_1089400# RPP W=2.4e-06 L=0.0002142855
XR38B a_628571_1089400# a_1057142_1083400# RPP W=2.4e-06 L=0.0002142855
XR39A a_161400_1089400# a_165000_1089400# RPP W=2.4e-06 L=0.0002142855
XR39B a_165000_1089400# a_593571_1083400# RPP W=2.4e-06 L=0.0002142855
XR40A a_624971_1089400# a_628571_1095400# RPP W=2.4e-06 L=0.0002142855
XR40B a_628571_1095400# a_1057142_1095400# RPP W=2.4e-06 L=0.0002142855
XR41A a_161400_1089400# a_165000_1095400# RPP W=2.4e-06 L=0.0002142855
XR41B a_165000_1095400# a_593571_1095400# RPP W=2.4e-06 L=0.0002142855
XR42A a_624971_1101400# a_628571_1101400# RPP W=2.4e-06 L=0.0002142855
XR42B a_628571_1101400# a_1057142_1095400# RPP W=2.4e-06 L=0.0002142855
XR43A a_161400_1101400# a_165000_1101400# RPP W=2.4e-06 L=0.0002142855
XR43B a_165000_1101400# a_593571_1095400# RPP W=2.4e-06 L=0.0002142855
XR44A a_624971_1101400# a_628571_1107400# RPP W=2.4e-06 L=0.0002142855
XR44B a_628571_1107400# a_1057142_1107400# RPP W=2.4e-06 L=0.0002142855
XR45A a_161400_1101400# a_165000_1107400# RPP W=2.4e-06 L=0.0002142855
XR45B a_165000_1107400# a_593571_1107400# RPP W=2.4e-06 L=0.0002142855
XR46A a_624971_1113400# a_628571_1113400# RPP W=2.4e-06 L=0.0002142855
XR46B a_628571_1113400# a_1057142_1107400# RPP W=2.4e-06 L=0.0002142855
XR47A a_161400_1113400# a_165000_1113400# RPP W=2.4e-06 L=0.0002142855
XR47B a_165000_1113400# a_593571_1107400# RPP W=2.4e-06 L=0.0002142855
XR48A a_624971_1113400# a_628571_1119400# RPP W=2.4e-06 L=0.0002142855
XR48B a_628571_1119400# a_1057142_1119400# RPP W=2.4e-06 L=0.0002142855
XR49A a_161400_1113400# a_165000_1119400# RPP W=2.4e-06 L=0.0002142855
XR49B a_165000_1119400# a_593571_1119400# RPP W=2.4e-06 L=0.0002142855
XR50A a_624971_1125400# a_628571_1125400# RPP W=2.4e-06 L=0.0002142855
XR50B a_628571_1125400# a_1057142_1119400# RPP W=2.4e-06 L=0.0002142855
XR51A a_161400_1125400# a_165000_1125400# RPP W=2.4e-06 L=0.0002142855
XR51B a_165000_1125400# a_593571_1119400# RPP W=2.4e-06 L=0.0002142855
XR52A a_624971_1125400# a_628571_1131400# RPP W=2.4e-06 L=0.0002142855
XR52B a_628571_1131400# a_1057142_1131400# RPP W=2.4e-06 L=0.0002142855
XR53A a_161400_1125400# a_165000_1131400# RPP W=2.4e-06 L=0.0002142855
XR53B a_165000_1131400# a_593571_1131400# RPP W=2.4e-06 L=0.0002142855
XR54A a_624971_1137400# a_628571_1137400# RPP W=2.4e-06 L=0.0002142855
XR54B a_628571_1137400# a_1057142_1131400# RPP W=2.4e-06 L=0.0002142855
XR55A a_161400_1137400# a_165000_1137400# RPP W=2.4e-06 L=0.0002142855
XR55B a_165000_1137400# a_593571_1131400# RPP W=2.4e-06 L=0.0002142855
XR56A a_624971_1137400# a_628571_1143400# RPP W=2.4e-06 L=0.0002142855
XR56B a_628571_1143400# a_1057142_1143400# RPP W=2.4e-06 L=0.0002142855
XR57A a_161400_1137400# a_165000_1143400# RPP W=2.4e-06 L=0.0002142855
XR57B a_165000_1143400# a_593571_1143400# RPP W=2.4e-06 L=0.0002142855
XR58A a_624971_1149400# a_628571_1149400# RPP W=2.4e-06 L=0.0002142855
XR58B a_628571_1149400# a_1057142_1143400# RPP W=2.4e-06 L=0.0002142855
XR59A a_161400_1149400# a_165000_1149400# RPP W=2.4e-06 L=0.0002142855
XR59B a_165000_1149400# a_593571_1143400# RPP W=2.4e-06 L=0.0002142855
XR60A a_624971_1149400# a_628571_1155400# RPP W=2.4e-06 L=0.0002142855
XR60B a_628571_1155400# a_1057142_1155400# RPP W=2.4e-06 L=0.0002142855
XR61A a_161400_1149400# a_165000_1155400# RPP W=2.4e-06 L=0.0002142855
XR61B a_165000_1155400# a_593571_1155400# RPP W=2.4e-06 L=0.0002142855
XR62A a_624971_1161400# a_628571_1161400# RPP W=2.4e-06 L=0.0002142855
XR62B a_628571_1161400# a_1057142_1155400# RPP W=2.4e-06 L=0.0002142855
XR63A a_161400_1161400# a_165000_1161400# RPP W=2.4e-06 L=0.0002142855
XR63B a_165000_1161400# a_593571_1155400# RPP W=2.4e-06 L=0.0002142855
XR64A a_624971_1161400# a_628571_1167400# RPP W=2.4e-06 L=0.0002142855
XR64B a_628571_1167400# a_1057142_1167400# RPP W=2.4e-06 L=0.0002142855
XR65A a_161400_1161400# a_165000_1167400# RPP W=2.4e-06 L=0.0002142855
XR65B a_165000_1167400# a_593571_1167400# RPP W=2.4e-06 L=0.0002142855
XR66A a_624971_1173400# a_628571_1173400# RPP W=2.4e-06 L=0.0002142855
XR66B a_628571_1173400# a_1057142_1167400# RPP W=2.4e-06 L=0.0002142855
XR67A a_161400_1173400# a_165000_1173400# RPP W=2.4e-06 L=0.0002142855
XR67B a_165000_1173400# a_593571_1167400# RPP W=2.4e-06 L=0.0002142855
XR68A a_624971_1173400# a_628571_1179400# RPP W=2.4e-06 L=0.0002142855
XR68B a_628571_1179400# a_1057142_1179400# RPP W=2.4e-06 L=0.0002142855
XR69A a_161400_1173400# a_165000_1179400# RPP W=2.4e-06 L=0.0002142855
XR69B a_165000_1179400# a_593571_1179400# RPP W=2.4e-06 L=0.0002142855
XR70A a_624971_1185400# a_628571_1185400# RPP W=2.4e-06 L=0.0002142855
XR70B a_628571_1185400# a_1057142_1179400# RPP W=2.4e-06 L=0.0002142855
XR71A a_161400_1185400# a_165000_1185400# RPP W=2.4e-06 L=0.0002142855
XR71B a_165000_1185400# a_593571_1179400# RPP W=2.4e-06 L=0.0002142855
XR72A a_624971_1185400# a_628571_1191400# RPP W=2.4e-06 L=0.0002142855
XR72B a_628571_1191400# a_1057142_1191400# RPP W=2.4e-06 L=0.0002142855
XR73A a_161400_1185400# a_165000_1191400# RPP W=2.4e-06 L=0.0002142855
XR73B a_165000_1191400# a_593571_1191400# RPP W=2.4e-06 L=0.0002142855
XR74A a_624971_1197400# a_628571_1197400# RPP W=2.4e-06 L=0.0002142855
XR74B a_628571_1197400# a_1057142_1191400# RPP W=2.4e-06 L=0.0002142855
XR75A a_161400_1197400# a_165000_1197400# RPP W=2.4e-06 L=0.0002142855
XR75B a_165000_1197400# a_593571_1191400# RPP W=2.4e-06 L=0.0002142855
XR76A a_624971_1197400# a_628571_1203400# RPP W=2.4e-06 L=0.0002142855
XR76B a_628571_1203400# a_1057142_1203400# RPP W=2.4e-06 L=0.0002142855
XR77A a_161400_1197400# a_165000_1203400# RPP W=2.4e-06 L=0.0002142855
XR77B a_165000_1203400# a_593571_1203400# RPP W=2.4e-06 L=0.0002142855
XR78A a_161400_1209400# a_628571_1209400# RPP W=2.4e-06 L=0.0002142855
XR78B a_628571_1209400# a_1057142_1203400# RPP W=2.4e-06 L=0.0002142855
XR79A a_161400_1209400# a_165000_1209400# RPP W=2.4e-06 L=0.0002142855
XR79B a_165000_1209400# a_593571_1203400# RPP W=2.4e-06 L=0.0002142855
.ends
