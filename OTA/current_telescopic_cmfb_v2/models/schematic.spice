* Same source transistor circuit; integrated bias diode, external cascode references.
.subckt ota_telescopic_layout INP INN OUTP OUTM VDD VSS IREF VCM VBN VBP
MSP VDD OUTP SP VSS N W=20u L=1.6u M=4 AD=90p AS=90p PD=49u PS=49u
MSM VDD OUTM SM VSS N W=20u L=1.6u M=4 AD=90p AS=90p PD=49u PS=49u
MSR VDD VCM SR VSS N W=20u L=1.6u M=4 AD=90p AS=90p PD=49u PS=49u
MSIP SP IREF VSS VSS N W=20u L=3.2u M=2 AD=90p AS=90p PD=49u PS=49u
MSIM SM IREF VSS VSS N W=20u L=3.2u M=2 AD=90p AS=90p PD=49u PS=49u
MSIR SR IREF VSS VSS N W=20u L=3.2u M=2 AD=90p AS=90p PD=49u PS=49u
XSP SP SENSE RPP W=2.4u L=17142.857142857u
XSM SM SENSE RPP W=2.4u L=17142.857142857u
MCBI CB CB VDD VDD P W=20u L=3.2u AD=90p AS=90p PD=49u PS=49u
MCBN CB IREF VSS VSS N W=11.428571u L=3.2u AD=51.4286p AS=51.4286p PD=31.8571u PS=31.8571u
MCC VDD PC VDD VDD P W=20u L=10u M=4 AD=90p AS=90p PD=49u PS=49u
MCM1 OUTP PC OUTP OUTP P W=20u L=10u AD=90p AS=90p PD=49u PS=49u M=12
MCM2 OUTM PC OUTM OUTM P W=20u L=10u AD=90p AS=90p PD=49u PS=49u M=12
MTAIL TAIL IREF VSS VSS N W=80.0u L=3.2u AD=360p AS=360p PD=169u PS=169u
MN1 NX1 INP TAIL VSS N W=15u L=2.4u AD=67.5p AS=67.5p PD=39u PS=39u
MN2 NX2 INN TAIL VSS N W=15u L=2.4u AD=67.5p AS=67.5p PD=39u PS=39u
MNC1 OUTM VBN NX1 VSS N W=30u L=2.4u AD=135p AS=135p PD=69u PS=69u
MNC2 OUTP VBN NX2 VSS N W=30u L=2.4u AD=135p AS=135p PD=69u PS=69u
MPC1 OUTM VBP PX1 VDD P W=60u L=2.4u AD=270p AS=270p PD=129u PS=129u
MPC2 OUTP VBP PX2 VDD P W=60u L=2.4u AD=270p AS=270p PD=129u PS=129u
MP1 PX1 PC VDD VDD P W=40u L=3.2u AD=180p AS=180p PD=89u PS=89u
MP2 PX2 PC VDD VDD P W=40u L=3.2u AD=180p AS=180p PD=89u PS=89u
MCS CA SENSE CT VDD P W=5u L=2.4u M=1 AD=22.5p AS=22.5p PD=19u PS=19u
MCR RCM SR CT VDD P W=5u L=2.4u M=1 AD=22.5p AS=22.5p PD=19u PS=19u
MCT CT CB VDD VDD P W=10u L=3.2u M=1 AD=45p AS=45p PD=29u PS=29u
MCFN1 CA CA VSS VSS N W=10u L=3.2u M=1 AD=45p AS=45p PD=29u PS=29u
MCFN2 PC CA VSS VSS N W=10u L=3.2u M=1 AD=45p AS=45p PD=29u PS=29u
MCFN3 RCM RCM VSS VSS N W=10u L=3.2u M=1 AD=45p AS=45p PD=29u PS=29u
MCFN4 PBIAS RCM VSS VSS N W=10u L=3.2u M=1 AD=45p AS=45p PD=29u PS=29u
MCFP1 PBIAS PBIAS VDD VDD P W=10u L=3.2u M=1 AD=45p AS=45p PD=29u PS=29u
MCFP2 PC PBIAS VDD VDD P W=10u L=3.2u M=1 AD=45p AS=45p PD=29u PS=29u
MREF IREF IREF VSS VSS N W=20u L=3.2u AD=90p AS=90p PD=49u PS=49u
.ends ota_telescopic_layout
