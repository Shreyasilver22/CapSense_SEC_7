.subckt ota_telescopic_layout INP INN OUTP OUTM VDD VSS IREF VCM VBN VBP
MSP VSS OUTP SP VDD P W=40u L=1.6u AD=180p AS=180p PD=89u PS=89u M=4
MSM VSS OUTM SM VDD P W=40u L=1.6u AD=180p AS=180p PD=89u PS=89u M=4
MSR VSS VCM SR VDD P W=40u L=1.6u AD=180p AS=180p PD=89u PS=89u M=4
MSIP SP CB VDD VDD P W=40u L=3.2u AD=180p AS=180p PD=89u PS=89u M=2
MSIM SM CB VDD VDD P W=40u L=3.2u AD=180p AS=180p PD=89u PS=89u M=2
MSIR SR CB VDD VDD P W=40u L=3.2u AD=180p AS=180p PD=89u PS=89u M=2
XSPA0 SP XSPC0 RPP W=2.4u L=428.571428571u
XSPB0 XSPC0 XSP1 RPP W=2.4u L=428.571428571u
CXSP0 XSPC0 VSS 273.83040000f
XSPA1 XSP1 XSPC1 RPP W=2.4u L=428.571428571u
XSPB1 XSPC1 XSP2 RPP W=2.4u L=428.571428571u
CXSP1 XSPC1 VSS 273.83040000f
XSPA2 XSP2 XSPC2 RPP W=2.4u L=428.571428571u
XSPB2 XSPC2 XSP3 RPP W=2.4u L=428.571428571u
CXSP2 XSPC2 VSS 273.83040000f
XSPA3 XSP3 XSPC3 RPP W=2.4u L=428.571428571u
XSPB3 XSPC3 XSP4 RPP W=2.4u L=428.571428571u
CXSP3 XSPC3 VSS 273.83040000f
XSPA4 XSP4 XSPC4 RPP W=2.4u L=428.571428571u
XSPB4 XSPC4 XSP5 RPP W=2.4u L=428.571428571u
CXSP4 XSPC4 VSS 273.83040000f
XSPA5 XSP5 XSPC5 RPP W=2.4u L=428.571428571u
XSPB5 XSPC5 XSP6 RPP W=2.4u L=428.571428571u
CXSP5 XSPC5 VSS 273.83040000f
XSPA6 XSP6 XSPC6 RPP W=2.4u L=428.571428571u
XSPB6 XSPC6 XSP7 RPP W=2.4u L=428.571428571u
CXSP6 XSPC6 VSS 273.83040000f
XSPA7 XSP7 XSPC7 RPP W=2.4u L=428.571428571u
XSPB7 XSPC7 XSP8 RPP W=2.4u L=428.571428571u
CXSP7 XSPC7 VSS 273.83040000f
XSPA8 XSP8 XSPC8 RPP W=2.4u L=428.571428571u
XSPB8 XSPC8 XSP9 RPP W=2.4u L=428.571428571u
CXSP8 XSPC8 VSS 273.83040000f
XSPA9 XSP9 XSPC9 RPP W=2.4u L=428.571428571u
XSPB9 XSPC9 XSP10 RPP W=2.4u L=428.571428571u
CXSP9 XSPC9 VSS 273.83040000f
XSPA10 XSP10 XSPC10 RPP W=2.4u L=428.571428571u
XSPB10 XSPC10 XSP11 RPP W=2.4u L=428.571428571u
CXSP10 XSPC10 VSS 273.83040000f
XSPA11 XSP11 XSPC11 RPP W=2.4u L=428.571428571u
XSPB11 XSPC11 XSP12 RPP W=2.4u L=428.571428571u
CXSP11 XSPC11 VSS 273.83040000f
XSPA12 XSP12 XSPC12 RPP W=2.4u L=428.571428571u
XSPB12 XSPC12 XSP13 RPP W=2.4u L=428.571428571u
CXSP12 XSPC12 VSS 273.83040000f
XSPA13 XSP13 XSPC13 RPP W=2.4u L=428.571428571u
XSPB13 XSPC13 XSP14 RPP W=2.4u L=428.571428571u
CXSP13 XSPC13 VSS 273.83040000f
XSPA14 XSP14 XSPC14 RPP W=2.4u L=428.571428571u
XSPB14 XSPC14 XSP15 RPP W=2.4u L=428.571428571u
CXSP14 XSPC14 VSS 273.83040000f
XSPA15 XSP15 XSPC15 RPP W=2.4u L=428.571428571u
XSPB15 XSPC15 XSP16 RPP W=2.4u L=428.571428571u
CXSP15 XSPC15 VSS 273.83040000f
XSPA16 XSP16 XSPC16 RPP W=2.4u L=428.571428571u
XSPB16 XSPC16 XSP17 RPP W=2.4u L=428.571428571u
CXSP16 XSPC16 VSS 273.83040000f
XSPA17 XSP17 XSPC17 RPP W=2.4u L=428.571428571u
XSPB17 XSPC17 XSP18 RPP W=2.4u L=428.571428571u
CXSP17 XSPC17 VSS 273.83040000f
XSPA18 XSP18 XSPC18 RPP W=2.4u L=428.571428571u
XSPB18 XSPC18 XSP19 RPP W=2.4u L=428.571428571u
CXSP18 XSPC18 VSS 273.83040000f
XSPA19 XSP19 XSPC19 RPP W=2.4u L=428.571428571u
XSPB19 XSPC19 SENSE RPP W=2.4u L=428.571428571u
CXSP19 XSPC19 VSS 273.83040000f
XSMA0 SM XSMC0 RPP W=2.4u L=428.571428571u
XSMB0 XSMC0 XSM1 RPP W=2.4u L=428.571428571u
CXSM0 XSMC0 VSS 273.83040000f
XSMA1 XSM1 XSMC1 RPP W=2.4u L=428.571428571u
XSMB1 XSMC1 XSM2 RPP W=2.4u L=428.571428571u
CXSM1 XSMC1 VSS 273.83040000f
XSMA2 XSM2 XSMC2 RPP W=2.4u L=428.571428571u
XSMB2 XSMC2 XSM3 RPP W=2.4u L=428.571428571u
CXSM2 XSMC2 VSS 273.83040000f
XSMA3 XSM3 XSMC3 RPP W=2.4u L=428.571428571u
XSMB3 XSMC3 XSM4 RPP W=2.4u L=428.571428571u
CXSM3 XSMC3 VSS 273.83040000f
XSMA4 XSM4 XSMC4 RPP W=2.4u L=428.571428571u
XSMB4 XSMC4 XSM5 RPP W=2.4u L=428.571428571u
CXSM4 XSMC4 VSS 273.83040000f
XSMA5 XSM5 XSMC5 RPP W=2.4u L=428.571428571u
XSMB5 XSMC5 XSM6 RPP W=2.4u L=428.571428571u
CXSM5 XSMC5 VSS 273.83040000f
XSMA6 XSM6 XSMC6 RPP W=2.4u L=428.571428571u
XSMB6 XSMC6 XSM7 RPP W=2.4u L=428.571428571u
CXSM6 XSMC6 VSS 273.83040000f
XSMA7 XSM7 XSMC7 RPP W=2.4u L=428.571428571u
XSMB7 XSMC7 XSM8 RPP W=2.4u L=428.571428571u
CXSM7 XSMC7 VSS 273.83040000f
XSMA8 XSM8 XSMC8 RPP W=2.4u L=428.571428571u
XSMB8 XSMC8 XSM9 RPP W=2.4u L=428.571428571u
CXSM8 XSMC8 VSS 273.83040000f
XSMA9 XSM9 XSMC9 RPP W=2.4u L=428.571428571u
XSMB9 XSMC9 XSM10 RPP W=2.4u L=428.571428571u
CXSM9 XSMC9 VSS 273.83040000f
XSMA10 XSM10 XSMC10 RPP W=2.4u L=428.571428571u
XSMB10 XSMC10 XSM11 RPP W=2.4u L=428.571428571u
CXSM10 XSMC10 VSS 273.83040000f
XSMA11 XSM11 XSMC11 RPP W=2.4u L=428.571428571u
XSMB11 XSMC11 XSM12 RPP W=2.4u L=428.571428571u
CXSM11 XSMC11 VSS 273.83040000f
XSMA12 XSM12 XSMC12 RPP W=2.4u L=428.571428571u
XSMB12 XSMC12 XSM13 RPP W=2.4u L=428.571428571u
CXSM12 XSMC12 VSS 273.83040000f
XSMA13 XSM13 XSMC13 RPP W=2.4u L=428.571428571u
XSMB13 XSMC13 XSM14 RPP W=2.4u L=428.571428571u
CXSM13 XSMC13 VSS 273.83040000f
XSMA14 XSM14 XSMC14 RPP W=2.4u L=428.571428571u
XSMB14 XSMC14 XSM15 RPP W=2.4u L=428.571428571u
CXSM14 XSMC14 VSS 273.83040000f
XSMA15 XSM15 XSMC15 RPP W=2.4u L=428.571428571u
XSMB15 XSMC15 XSM16 RPP W=2.4u L=428.571428571u
CXSM15 XSMC15 VSS 273.83040000f
XSMA16 XSM16 XSMC16 RPP W=2.4u L=428.571428571u
XSMB16 XSMC16 XSM17 RPP W=2.4u L=428.571428571u
CXSM16 XSMC16 VSS 273.83040000f
XSMA17 XSM17 XSMC17 RPP W=2.4u L=428.571428571u
XSMB17 XSMC17 XSM18 RPP W=2.4u L=428.571428571u
CXSM17 XSMC17 VSS 273.83040000f
XSMA18 XSM18 XSMC18 RPP W=2.4u L=428.571428571u
XSMB18 XSMC18 XSM19 RPP W=2.4u L=428.571428571u
CXSM18 XSMC18 VSS 273.83040000f
XSMA19 XSM19 XSMC19 RPP W=2.4u L=428.571428571u
XSMB19 XSMC19 SENSE RPP W=2.4u L=428.571428571u
CXSM19 XSMC19 VSS 273.83040000f
MCS CA SENSE CT VSS N W=2.5u L=2.4u AD=11.25p AS=11.25p PD=14u PS=14u
MCR PC SR CT VSS N W=2.5u L=2.4u AD=11.25p AS=11.25p PD=14u PS=14u
MCBI CB CB VDD VDD P W=20u L=3.2u AD=90p AS=90p PD=49u PS=49u
MCBN CB IREF VSS VSS N W=11.428571u L=3.2u AD=51.4286p AS=51.4286p PD=31.8571u PS=31.8571u
MCT CT IREF VSS VSS N W=2.85714275u L=3.2u AD=12.8571424p AS=12.8571424p PD=14.7142855u PS=14.7142855u
MCP1 CA CA VDD VDD P W=5u L=3.2u AD=22.5p AS=22.5p PD=19u PS=19u
MCP2 PC CA VDD VDD P W=5u L=3.2u AD=22.5p AS=22.5p PD=19u PS=19u
MCC VDD PC VDD VDD P W=20u L=10u M=4 AD=90p AS=90p PD=49u PS=49u
MCM1 OUTP PC OUTP OUTP P W=20u L=10u AD=90p AS=90p PD=49u PS=49u M=6
MCM2 OUTM PC OUTM OUTM P W=20u L=10u AD=90p AS=90p PD=49u PS=49u M=6
MTAIL TAIL IREF VSS VSS N W=80.0u L=3.2u AD=360p AS=360p PD=169u PS=169u
MN1 NX1 INP TAIL VSS N W=15u L=2.4u AD=67.5p AS=67.5p PD=39u PS=39u
MN2 NX2 INN TAIL VSS N W=15u L=2.4u AD=67.5p AS=67.5p PD=39u PS=39u
MNC1 OUTM VBN NX1 VSS N W=30u L=2.4u AD=135p AS=135p PD=69u PS=69u
MNC2 OUTP VBN NX2 VSS N W=30u L=2.4u AD=135p AS=135p PD=69u PS=69u
MPC1 OUTM VBP PX1 VDD P W=60u L=2.4u AD=270p AS=270p PD=129u PS=129u
MPC2 OUTP VBP PX2 VDD P W=60u L=2.4u AD=270p AS=270p PD=129u PS=129u
MP1 PX1 PC VDD VDD P W=40u L=3.2u AD=180p AS=180p PD=89u PS=89u
MP2 PX2 PC VDD VDD P W=40u L=3.2u AD=180p AS=180p PD=89u PS=89u
CPAR_sense SENSE VSS 0.1p
CPAR_pc PC VSS 0.3p
CPAR_sp SP VSS 0.1p
CPAR_sm SM VSS 0.1p
CPAR_op OUTP VSS 0.5p
CPAR_om OUTM VSS 0.5p
MREF IREF IREF VSS VSS N W=20u L=3.2u AD=90p AS=90p PD=49u PS=49u
.ends ota_telescopic_layout
