.subckt ota_telescopic_layout INP INN OUTP OUTM VDD VSS IREF VCM VBN VBP
MSP VDD OUTP SP VSS N w=20u l=1.6u AD=90p AS=90p PD=49u PS=49u m=4
MSM VDD OUTM SM VSS N w=20u l=1.6u AD=90p AS=90p PD=49u PS=49u m=4
MSR VDD VCM SR VSS N w=20u l=1.6u AD=90p AS=90p PD=49u PS=49u m=4
MSIP SP IREF VSS VSS N w=20u l=3.2u AD=90p AS=90p PD=49u PS=49u m=2
MSIM SM IREF VSS VSS N w=20u l=3.2u AD=90p AS=90p PD=49u PS=49u m=2
MSIR SR IREF VSS VSS N w=20u l=3.2u AD=90p AS=90p PD=49u PS=49u m=2
MCBI CB CB VDD VDD P w=20u l=3.2u AD=90p AS=90p PD=49u PS=49u m=1
MCBN CB IREF VSS VSS N w=11.428571u l=3.2u AD=51.4286p AS=51.4286p PD=31.8571u PS=31.8571u m=1
MCC VDD PC VDD VDD P w=20u l=10u AD=90p AS=90p PD=49u PS=49u m=4
MCM1 OUTP PC OUTP OUTP P w=20u l=10u AD=90p AS=90p PD=49u PS=49u m=12
MCM2 OUTM PC OUTM OUTM P w=20u l=10u AD=90p AS=90p PD=49u PS=49u m=12
MTAIL TAIL IREF VSS VSS N w=80.0u l=3.2u AD=360p AS=360p PD=169u PS=169u m=1
MN1 NX1 INP TAIL VSS N w=15u l=2.4u AD=67.5p AS=67.5p PD=39u PS=39u m=1
MN2 NX2 INN TAIL VSS N w=15u l=2.4u AD=67.5p AS=67.5p PD=39u PS=39u m=1
MNC1 OUTM VBN NX1 VSS N w=30u l=2.4u AD=135p AS=135p PD=69u PS=69u m=1
MNC2 OUTP VBN NX2 VSS N w=30u l=2.4u AD=135p AS=135p PD=69u PS=69u m=1
MPC1 OUTM VBP PX1 VDD P w=60u l=2.4u AD=270p AS=270p PD=129u PS=129u m=1
MPC2 OUTP VBP PX2 VDD P w=60u l=2.4u AD=270p AS=270p PD=129u PS=129u m=1
MP1 PX1 PC VDD VDD P w=40u l=3.2u AD=180p AS=180p PD=89u PS=89u m=1
MP2 PX2 PC VDD VDD P w=40u l=3.2u AD=180p AS=180p PD=89u PS=89u m=1
MCS CA SENSE CT VDD P w=5u l=2.4u AD=22.5p AS=22.5p PD=19u PS=19u m=1
MCR RCM SR CT VDD P w=5u l=2.4u AD=22.5p AS=22.5p PD=19u PS=19u m=1
MCT CT CB VDD VDD P w=10u l=3.2u AD=45p AS=45p PD=29u PS=29u m=1
MCFN1 CA CA VSS VSS N w=10u l=3.2u AD=45p AS=45p PD=29u PS=29u m=1
MCFN2 PC CA VSS VSS N w=10u l=3.2u AD=45p AS=45p PD=29u PS=29u m=1
MCFN3 RCM RCM VSS VSS N w=10u l=3.2u AD=45p AS=45p PD=29u PS=29u m=1
MCFN4 PBIAS RCM VSS VSS N w=10u l=3.2u AD=45p AS=45p PD=29u PS=29u m=1
MCFP1 PBIAS PBIAS VDD VDD P w=10u l=3.2u AD=45p AS=45p PD=29u PS=29u m=1
MCFP2 PC PBIAS VDD VDD P w=10u l=3.2u AD=45p AS=45p PD=29u PS=29u m=1
MREF IREF IREF VSS VSS N w=20u l=3.2u AD=90p AS=90p PD=49u PS=49u m=1
RXSP SP SENSE 200000.0000016667 RPP
RXSM SM SENSE 200000.0000016667 RPP
.ends ota_telescopic_layout
