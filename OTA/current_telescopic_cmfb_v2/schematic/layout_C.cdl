* NGSPICE file created from ota_telescopic_layout.ext - technology: SCL_CP8D

.subckt ota_telescopic_layout INP INN OUTP OUTM VDD VSS IREF VCM VBN VBP
M1000 VDD OUTM a_166200_473000# VSS N w=20u l=1.6u
+  ad=90.00001p pd=49u as=90.00001p ps=49u
M1001 OUTP a_163000_528900# OUTP OUTP P w=20u l=10u
+  ad=90.00001p pd=49u as=-1.86497n ps=1.305m
M1002 OUTP a_163000_528900# OUTP OUTP P w=20u l=10u
+  ad=90.00001p pd=49u as=-0 ps=0
M1003 a_163000_868700# IREF VSS VSS N w=11.429u l=3.2u
+  ad=51.4305p pd=31.858u as=51.4305p ps=31.858u
M1004 OUTP a_163000_528900# OUTP OUTP P w=20u l=10u
+  ad=90.00001p pd=49u as=-0 ps=0
M1005 VDD a_163000_528900# VDD VDD P w=20u l=10u
+  ad=90.00001p pd=49u as=1.305n ps=0.706m
M1006 a_200200_868700# a_200200_868700# VSS VSS N w=10u l=3.2u
+  ad=45p pd=29u as=45p ps=29u
M1007 a_239000_71400# INN a_166200_71400# VSS N w=15u l=2.4u
+  ad=67.50001p pd=39u as=67.50001p ps=39u
M1008 a_158500_217600# a_163000_528900# VDD VDD P w=40u l=3.2u
+  ad=0.18n pd=89u as=0.18n ps=89u
M1009 OUTM a_163000_528900# OUTM OUTM P w=20u l=10u
+  ad=90.00001p pd=49u as=-1.86497n ps=1.305m
M1010 OUTP a_163000_528900# OUTP OUTP P w=20u l=10u
+  ad=90.00001p pd=49u as=-0 ps=0
M1011 OUTM a_163000_528900# OUTM OUTM P w=20u l=10u
+  ad=90.00001p pd=49u as=-0 ps=0
M1012 OUTM a_163000_528900# OUTM OUTM P w=20u l=10u
+  ad=90.00001p pd=49u as=-0 ps=0
M1013 OUTM a_163000_528900# OUTM OUTM P w=20u l=10u
+  ad=90.00001p pd=49u as=-0 ps=0
M1014 a_274600_868700# a_274600_868700# VSS VSS N w=10u l=3.2u
+  ad=45p pd=29u as=45p ps=29u
M1015 OUTP VBN a_239000_71400# VSS N w=30u l=2.4u
+  ad=0.135n pd=69u as=0.135n ps=69u
M1016 VDD OUTM a_166200_473000# VSS N w=20u l=1.6u
+  ad=90.00001p pd=49u as=90.00001p ps=49u
M1017 VDD OUTM a_166200_473000# VSS N w=20u l=1.6u
+  ad=90.00001p pd=49u as=90.00001p ps=49u
M1018 VDD OUTP a_158500_329400# VSS N w=20u l=1.6u
+  ad=90.00001p pd=49u as=90.00001p ps=49u
M1019 a_163000_916100# a_163000_916100# VDD VDD P w=10u l=3.2u
+  ad=45p pd=29u as=45p ps=29u
M1020 VDD a_163000_528900# VDD VDD P w=20u l=10u
+  ad=90.00001p pd=49u as=0 ps=0
M1021 OUTP a_163000_528900# OUTP OUTP P w=20u l=10u
+  ad=90.00001p pd=49u as=-0 ps=0
M1022 OUTP a_163000_528900# OUTP OUTP P w=20u l=10u
+  ad=90.00001p pd=49u as=-0 ps=0
M1023 VDD VCM a_158500_401200# VSS N w=20u l=1.6u
+  ad=90.00001p pd=49u as=90.00001p ps=49u
M1024 VDD VCM a_158500_401200# VSS N w=20u l=1.6u
+  ad=90.00001p pd=49u as=90.00001p ps=49u
M1025 OUTP a_163000_528900# OUTP OUTP P w=20u l=10u
+  ad=90.00001p pd=49u as=-0 ps=0
M1026 a_166200_473000# IREF VSS VSS N w=20u l=3.2u
+  ad=90.00001p pd=49u as=90.00001p ps=49u
M1027 a_163000_528900# a_200200_868700# VSS VSS N w=10u l=3.2u
+  ad=45p pd=29u as=45p ps=29u
M1028 a_200200_868700# a_161400_1209400# a_166200_870200# VDD P w=5u l=2.4u
+  ad=22.5p pd=19u as=22.5p ps=19u
M1029 a_158500_329400# IREF VSS VSS N w=20u l=3.2u
+  ad=90.00001p pd=49u as=90.00001p ps=49u
M1030 VDD a_163000_528900# VDD VDD P w=20u l=10u
+  ad=90.00001p pd=49u as=0 ps=0
M1031 VDD OUTP a_158500_329400# VSS N w=20u l=1.6u
+  ad=90.00001p pd=49u as=90.00001p ps=49u
M1032 a_163000_916100# a_274600_868700# VSS VSS N w=10u l=3.2u
+  ad=45p pd=29u as=45p ps=29u
M1033 OUTM VBN a_202600_71400# VSS N w=30u l=2.4u
+  ad=0.135n pd=69u as=0.135n ps=69u
M1034 a_158500_329400# IREF VSS VSS N w=20u l=3.2u
+  ad=90.00001p pd=49u as=90.00001p ps=49u
M1035 VDD VCM a_158500_401200# VSS N w=20u l=1.6u
+  ad=90.00001p pd=49u as=90.00001p ps=49u
M1036 VDD VCM a_158500_401200# VSS N w=20u l=1.6u
+  ad=90.00001p pd=49u as=90.00001p ps=49u
M1037 a_166200_473000# IREF VSS VSS N w=20u l=3.2u
+  ad=90.00001p pd=49u as=90.00001p ps=49u
M1038 VDD OUTP a_158500_329400# VSS N w=20u l=1.6u
+  ad=90.00001p pd=49u as=90.00001p ps=49u
M1039 a_166200_71400# IREF VSS VSS N w=80.00001u l=3.2u
+  ad=0.36n pd=0.169m as=0.36n ps=0.169m
M1040 a_158500_401200# IREF VSS VSS N w=20u l=3.2u
+  ad=90.00001p pd=49u as=90.00001p ps=49u
M1041 OUTP VBP a_158500_217600# VDD P w=60u l=2.4u
+  ad=0.27n pd=0.129m as=0.27n ps=0.129m
M1042 OUTM VBP a_202600_217600# VDD P w=60u l=2.4u
+  ad=0.27n pd=0.129m as=0.27n ps=0.129m
M1043 a_163000_868700# a_163000_868700# VDD VDD P w=20u l=3.2u
+  ad=90.00001p pd=49u as=90.00001p ps=49u
M1044 a_166200_870200# a_163000_868700# VDD VDD P w=10u l=3.2u
+  ad=45p pd=29u as=45p ps=29u
M1045 a_202600_217600# a_163000_528900# VDD VDD P w=40u l=3.2u
+  ad=0.18n pd=89u as=0.18n ps=89u
M1046 OUTM a_163000_528900# OUTM OUTM P w=20u l=10u
+  ad=90.00001p pd=49u as=-0 ps=0
M1047 OUTM a_163000_528900# OUTM OUTM P w=20u l=10u
+  ad=90.00001p pd=49u as=-0 ps=0
M1048 a_158500_401200# IREF VSS VSS N w=20u l=3.2u
+  ad=90.00001p pd=49u as=90.00001p ps=49u
M1049 OUTM a_163000_528900# OUTM OUTM P w=20u l=10u
+  ad=90.00001p pd=49u as=-0 ps=0
M1050 OUTM a_163000_528900# OUTM OUTM P w=20u l=10u
+  ad=90.00001p pd=49u as=-0 ps=0
M1051 OUTM a_163000_528900# OUTM OUTM P w=20u l=10u
+  ad=90.00001p pd=49u as=-0 ps=0
M1052 OUTP a_163000_528900# OUTP OUTP P w=20u l=10u
+  ad=90.00001p pd=49u as=-0 ps=0
M1053 IREF IREF VSS VSS N w=20u l=3.2u
+  ad=90.00001p pd=49u as=90.00001p ps=49u
M1054 OUTP a_163000_528900# OUTP OUTP P w=20u l=10u
+  ad=90.00001p pd=49u as=-0 ps=0
M1055 OUTM a_163000_528900# OUTM OUTM P w=20u l=10u
+  ad=90.00001p pd=49u as=-0 ps=0
M1056 OUTP a_163000_528900# OUTP OUTP P w=20u l=10u
+  ad=90.00001p pd=49u as=-0 ps=0
M1057 OUTM a_163000_528900# OUTM OUTM P w=20u l=10u
+  ad=90.00001p pd=49u as=-0 ps=0
M1058 OUTP a_163000_528900# OUTP OUTP P w=20u l=10u
+  ad=90.00001p pd=49u as=-0 ps=0
M1059 a_202600_71400# INP a_166200_71400# VSS N w=15u l=2.4u
+  ad=67.50001p pd=39u as=67.50001p ps=39u
M1060 OUTM a_163000_528900# OUTM OUTM P w=20u l=10u
+  ad=90.00001p pd=49u as=-0 ps=0
M1061 OUTP a_163000_528900# OUTP OUTP P w=20u l=10u
+  ad=90.00001p pd=49u as=-0 ps=0
M1062 a_274600_868700# a_158500_401200# a_166200_870200# VDD P w=5u l=2.4u
+  ad=22.5p pd=19u as=22.5p ps=19u
M1063 a_163000_528900# a_163000_916100# VDD VDD P w=10u l=3.2u
+  ad=45p pd=29u as=45p ps=29u
M1064 VDD OUTM a_166200_473000# VSS N w=20u l=1.6u
+  ad=90.00001p pd=49u as=90.00001p ps=49u
M1065 VDD OUTP a_158500_329400# VSS N w=20u l=1.6u
+  ad=90.00001p pd=49u as=90.00001p ps=49u
M1066 VDD a_163000_528900# VDD VDD P w=20u l=10u
+  ad=90.00001p pd=49u as=0 ps=0
RXR0A a_166200_473000# a_628571_975400# 2499.9975 RPP
RXR0B a_628571_975400# a_1057142_975400# 2499.9975 RPP
RXR1A a_158500_329400# a_165000_975400# 2499.9975 RPP
RXR1B a_165000_975400# a_593571_975400# 2499.9975 RPP
RXR2A a_624971_981400# a_628571_981400# 2499.9975 RPP
RXR2B a_628571_981400# a_1057142_975400# 2499.9975 RPP
RXR3A a_161400_981400# a_165000_981400# 2499.9975 RPP
RXR3B a_165000_981400# a_593571_975400# 2499.9975 RPP
RXR4A a_624971_981400# a_628571_987400# 2499.9975 RPP
RXR4B a_628571_987400# a_1057142_987400# 2499.9975 RPP
RXR5A a_161400_981400# a_165000_987400# 2499.9975 RPP
RXR5B a_165000_987400# a_593571_987400# 2499.9975 RPP
RXR6A a_624971_993400# a_628571_993400# 2499.9975 RPP
RXR6B a_628571_993400# a_1057142_987400# 2499.9975 RPP
RXR7A a_161400_993400# a_165000_993400# 2499.9975 RPP
RXR7B a_165000_993400# a_593571_987400# 2499.9975 RPP
RXR8A a_624971_993400# a_628571_999400# 2499.9975 RPP
RXR8B a_628571_999400# a_1057142_999400# 2499.9975 RPP
RXR9A a_161400_993400# a_165000_999400# 2499.9975 RPP
RXR9B a_165000_999400# a_593571_999400# 2499.9975 RPP
RXR10A a_624971_1005400# a_628571_1005400# 2499.9975 RPP
RXR10B a_628571_1005400# a_1057142_999400# 2499.9975 RPP
RXR11A a_161400_1005400# a_165000_1005400# 2499.9975 RPP
RXR11B a_165000_1005400# a_593571_999400# 2499.9975 RPP
RXR12A a_624971_1005400# a_628571_1011400# 2499.9975 RPP
RXR12B a_628571_1011400# a_1057142_1011400# 2499.9975 RPP
RXR13A a_161400_1005400# a_165000_1011400# 2499.9975 RPP
RXR13B a_165000_1011400# a_593571_1011400# 2499.9975 RPP
RXR14A a_624971_1017400# a_628571_1017400# 2499.9975 RPP
RXR14B a_628571_1017400# a_1057142_1011400# 2499.9975 RPP
RXR15A a_161400_1017400# a_165000_1017400# 2499.9975 RPP
RXR15B a_165000_1017400# a_593571_1011400# 2499.9975 RPP
RXR16A a_624971_1017400# a_628571_1023400# 2499.9975 RPP
RXR16B a_628571_1023400# a_1057142_1023400# 2499.9975 RPP
RXR17A a_161400_1017400# a_165000_1023400# 2499.9975 RPP
RXR17B a_165000_1023400# a_593571_1023400# 2499.9975 RPP
RXR18A a_624971_1029400# a_628571_1029400# 2499.9975 RPP
RXR18B a_628571_1029400# a_1057142_1023400# 2499.9975 RPP
RXR19A a_161400_1029400# a_165000_1029400# 2499.9975 RPP
RXR19B a_165000_1029400# a_593571_1023400# 2499.9975 RPP
RXR20A a_624971_1029400# a_628571_1035400# 2499.9975 RPP
RXR20B a_628571_1035400# a_1057142_1035400# 2499.9975 RPP
RXR21A a_161400_1029400# a_165000_1035400# 2499.9975 RPP
RXR21B a_165000_1035400# a_593571_1035400# 2499.9975 RPP
RXR22A a_624971_1041400# a_628571_1041400# 2499.9975 RPP
RXR22B a_628571_1041400# a_1057142_1035400# 2499.9975 RPP
RXR23A a_161400_1041400# a_165000_1041400# 2499.9975 RPP
RXR23B a_165000_1041400# a_593571_1035400# 2499.9975 RPP
RXR24A a_624971_1041400# a_628571_1047400# 2499.9975 RPP
RXR24B a_628571_1047400# a_1057142_1047400# 2499.9975 RPP
RXR25A a_161400_1041400# a_165000_1047400# 2499.9975 RPP
RXR25B a_165000_1047400# a_593571_1047400# 2499.9975 RPP
RXR26A a_624971_1053400# a_628571_1053400# 2499.9975 RPP
RXR26B a_628571_1053400# a_1057142_1047400# 2499.9975 RPP
RXR27A a_161400_1053400# a_165000_1053400# 2499.9975 RPP
RXR27B a_165000_1053400# a_593571_1047400# 2499.9975 RPP
RXR28A a_624971_1053400# a_628571_1059400# 2499.9975 RPP
RXR28B a_628571_1059400# a_1057142_1059400# 2499.9975 RPP
RXR29A a_161400_1053400# a_165000_1059400# 2499.9975 RPP
RXR29B a_165000_1059400# a_593571_1059400# 2499.9975 RPP
RXR30A a_624971_1065400# a_628571_1065400# 2499.9975 RPP
RXR30B a_628571_1065400# a_1057142_1059400# 2499.9975 RPP
RXR31A a_161400_1065400# a_165000_1065400# 2499.9975 RPP
RXR31B a_165000_1065400# a_593571_1059400# 2499.9975 RPP
RXR32A a_624971_1065400# a_628571_1071400# 2499.9975 RPP
RXR32B a_628571_1071400# a_1057142_1071400# 2499.9975 RPP
RXR33A a_161400_1065400# a_165000_1071400# 2499.9975 RPP
RXR33B a_165000_1071400# a_593571_1071400# 2499.9975 RPP
RXR34A a_624971_1077400# a_628571_1077400# 2499.9975 RPP
RXR34B a_628571_1077400# a_1057142_1071400# 2499.9975 RPP
RXR35A a_161400_1077400# a_165000_1077400# 2499.9975 RPP
RXR35B a_165000_1077400# a_593571_1071400# 2499.9975 RPP
RXR36A a_624971_1077400# a_628571_1083400# 2499.9975 RPP
RXR36B a_628571_1083400# a_1057142_1083400# 2499.9975 RPP
RXR37A a_161400_1077400# a_165000_1083400# 2499.9975 RPP
RXR37B a_165000_1083400# a_593571_1083400# 2499.9975 RPP
RXR38A a_624971_1089400# a_628571_1089400# 2499.9975 RPP
RXR38B a_628571_1089400# a_1057142_1083400# 2499.9975 RPP
RXR39A a_161400_1089400# a_165000_1089400# 2499.9975 RPP
RXR39B a_165000_1089400# a_593571_1083400# 2499.9975 RPP
RXR40A a_624971_1089400# a_628571_1095400# 2499.9975 RPP
RXR40B a_628571_1095400# a_1057142_1095400# 2499.9975 RPP
RXR41A a_161400_1089400# a_165000_1095400# 2499.9975 RPP
RXR41B a_165000_1095400# a_593571_1095400# 2499.9975 RPP
RXR42A a_624971_1101400# a_628571_1101400# 2499.9975 RPP
RXR42B a_628571_1101400# a_1057142_1095400# 2499.9975 RPP
RXR43A a_161400_1101400# a_165000_1101400# 2499.9975 RPP
RXR43B a_165000_1101400# a_593571_1095400# 2499.9975 RPP
RXR44A a_624971_1101400# a_628571_1107400# 2499.9975 RPP
RXR44B a_628571_1107400# a_1057142_1107400# 2499.9975 RPP
RXR45A a_161400_1101400# a_165000_1107400# 2499.9975 RPP
RXR45B a_165000_1107400# a_593571_1107400# 2499.9975 RPP
RXR46A a_624971_1113400# a_628571_1113400# 2499.9975 RPP
RXR46B a_628571_1113400# a_1057142_1107400# 2499.9975 RPP
RXR47A a_161400_1113400# a_165000_1113400# 2499.9975 RPP
RXR47B a_165000_1113400# a_593571_1107400# 2499.9975 RPP
RXR48A a_624971_1113400# a_628571_1119400# 2499.9975 RPP
RXR48B a_628571_1119400# a_1057142_1119400# 2499.9975 RPP
RXR49A a_161400_1113400# a_165000_1119400# 2499.9975 RPP
RXR49B a_165000_1119400# a_593571_1119400# 2499.9975 RPP
RXR50A a_624971_1125400# a_628571_1125400# 2499.9975 RPP
RXR50B a_628571_1125400# a_1057142_1119400# 2499.9975 RPP
RXR51A a_161400_1125400# a_165000_1125400# 2499.9975 RPP
RXR51B a_165000_1125400# a_593571_1119400# 2499.9975 RPP
RXR52A a_624971_1125400# a_628571_1131400# 2499.9975 RPP
RXR52B a_628571_1131400# a_1057142_1131400# 2499.9975 RPP
RXR53A a_161400_1125400# a_165000_1131400# 2499.9975 RPP
RXR53B a_165000_1131400# a_593571_1131400# 2499.9975 RPP
RXR54A a_624971_1137400# a_628571_1137400# 2499.9975 RPP
RXR54B a_628571_1137400# a_1057142_1131400# 2499.9975 RPP
RXR55A a_161400_1137400# a_165000_1137400# 2499.9975 RPP
RXR55B a_165000_1137400# a_593571_1131400# 2499.9975 RPP
RXR56A a_624971_1137400# a_628571_1143400# 2499.9975 RPP
RXR56B a_628571_1143400# a_1057142_1143400# 2499.9975 RPP
RXR57A a_161400_1137400# a_165000_1143400# 2499.9975 RPP
RXR57B a_165000_1143400# a_593571_1143400# 2499.9975 RPP
RXR58A a_624971_1149400# a_628571_1149400# 2499.9975 RPP
RXR58B a_628571_1149400# a_1057142_1143400# 2499.9975 RPP
RXR59A a_161400_1149400# a_165000_1149400# 2499.9975 RPP
RXR59B a_165000_1149400# a_593571_1143400# 2499.9975 RPP
RXR60A a_624971_1149400# a_628571_1155400# 2499.9975 RPP
RXR60B a_628571_1155400# a_1057142_1155400# 2499.9975 RPP
RXR61A a_161400_1149400# a_165000_1155400# 2499.9975 RPP
RXR61B a_165000_1155400# a_593571_1155400# 2499.9975 RPP
RXR62A a_624971_1161400# a_628571_1161400# 2499.9975 RPP
RXR62B a_628571_1161400# a_1057142_1155400# 2499.9975 RPP
RXR63A a_161400_1161400# a_165000_1161400# 2499.9975 RPP
RXR63B a_165000_1161400# a_593571_1155400# 2499.9975 RPP
RXR64A a_624971_1161400# a_628571_1167400# 2499.9975 RPP
RXR64B a_628571_1167400# a_1057142_1167400# 2499.9975 RPP
RXR65A a_161400_1161400# a_165000_1167400# 2499.9975 RPP
RXR65B a_165000_1167400# a_593571_1167400# 2499.9975 RPP
RXR66A a_624971_1173400# a_628571_1173400# 2499.9975 RPP
RXR66B a_628571_1173400# a_1057142_1167400# 2499.9975 RPP
RXR67A a_161400_1173400# a_165000_1173400# 2499.9975 RPP
RXR67B a_165000_1173400# a_593571_1167400# 2499.9975 RPP
RXR68A a_624971_1173400# a_628571_1179400# 2499.9975 RPP
RXR68B a_628571_1179400# a_1057142_1179400# 2499.9975 RPP
RXR69A a_161400_1173400# a_165000_1179400# 2499.9975 RPP
RXR69B a_165000_1179400# a_593571_1179400# 2499.9975 RPP
RXR70A a_624971_1185400# a_628571_1185400# 2499.9975 RPP
RXR70B a_628571_1185400# a_1057142_1179400# 2499.9975 RPP
RXR71A a_161400_1185400# a_165000_1185400# 2499.9975 RPP
RXR71B a_165000_1185400# a_593571_1179400# 2499.9975 RPP
RXR72A a_624971_1185400# a_628571_1191400# 2499.9975 RPP
RXR72B a_628571_1191400# a_1057142_1191400# 2499.9975 RPP
RXR73A a_161400_1185400# a_165000_1191400# 2499.9975 RPP
RXR73B a_165000_1191400# a_593571_1191400# 2499.9975 RPP
RXR74A a_624971_1197400# a_628571_1197400# 2499.9975 RPP
RXR74B a_628571_1197400# a_1057142_1191400# 2499.9975 RPP
RXR75A a_161400_1197400# a_165000_1197400# 2499.9975 RPP
RXR75B a_165000_1197400# a_593571_1191400# 2499.9975 RPP
RXR76A a_624971_1197400# a_628571_1203400# 2499.9975 RPP
RXR76B a_628571_1203400# a_1057142_1203400# 2499.9975 RPP
RXR77A a_161400_1197400# a_165000_1203400# 2499.9975 RPP
RXR77B a_165000_1203400# a_593571_1203400# 2499.9975 RPP
RXR78A a_161400_1209400# a_628571_1209400# 2499.9975 RPP
RXR78B a_628571_1209400# a_1057142_1203400# 2499.9975 RPP
RXR79A a_161400_1209400# a_165000_1209400# 2499.9975 RPP
RXR79B a_165000_1209400# a_593571_1203400# 2499.9975 RPP
.ends
