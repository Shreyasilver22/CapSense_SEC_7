* Independent source-model reference, external cascode references and integrated bias diode.
.subckt ota_telescopic_layout INP INN OUTP OUTM VDD VSS IREF VCM VBN VBP
MSP VDD OUTP SP VSS N W=20.0u L=1.6u M=4
MSM VDD OUTM SM VSS N W=20.0u L=1.6u M=4
MSR VDD VCM SR VSS N W=20.0u L=1.6u M=4
MSIP SP IREF VSS VSS N W=20.0u L=3.2u M=2
MSIM SM IREF VSS VSS N W=20.0u L=3.2u M=2
MSIR SR IREF VSS VSS N W=20.0u L=3.2u M=2
MCBI CB CB VDD VDD P W=20.0u L=3.2u M=1
MCBN CB IREF VSS VSS N W=11.428571u L=3.2u M=1
MCC VDD PC VDD VDD P W=20.0u L=10.0u M=4
MCM1 OUTP PC OUTP OUTP P W=20.0u L=10.0u M=12
MCM2 OUTM PC OUTM OUTM P W=20.0u L=10.0u M=12
MTAIL TAIL IREF VSS VSS N W=80.0u L=3.2u M=1
MN1 NX1 VDD TAIL VSS N W=15.0u L=2.4u M=1
MN2 NX2 INN TAIL VSS N W=15.0u L=2.4u M=1
MNC1 OUTM VBN NX1 VSS N W=30.0u L=2.4u M=1
MNC2 OUTP VBN NX2 VSS N W=30.0u L=2.4u M=1
MPC1 OUTM VBP PX1 VDD P W=60.0u L=2.4u M=1
MPC2 OUTP VBP PX2 VDD P W=60.0u L=2.4u M=1
MP1 PX1 PC VDD VDD P W=40.0u L=3.2u M=1
MP2 PX2 PC VDD VDD P W=40.0u L=3.2u M=1
MCS CA SENSE CT VDD P W=5.0u L=2.4u M=1
MCR RCM SR CT VDD P W=5.0u L=2.4u M=1
MCT CT CB VDD VDD P W=10.0u L=3.2u M=1
MCFN1 CA CA VSS VSS N W=10.0u L=3.2u M=1
MCFN2 PC CA VSS VSS N W=10.0u L=3.2u M=1
MCFN3 RCM RCM VSS VSS N W=10.0u L=3.2u M=1
MCFN4 PBIAS RCM VSS VSS N W=10.0u L=3.2u M=1
MCFP1 PBIAS PBIAS VDD VDD P W=10.0u L=3.2u M=1
MCFP2 PC PBIAS VDD VDD P W=10.0u L=3.2u M=1
MREF IREF IREF VSS VSS N W=20u L=3.2u
RSP SP SENSE 200000 RPP
RSM SM SENSE 200000 RPP
.ends ota_telescopic_layout
