SCL08 seven transistor OTA first pass
.include "../spice/models.inc"
.include "../spice/ota7.inc"
.temp 27
VDD vdd 0 5
VBN vbn 0 0.95
CL out 0 5p
VCM cm 0 2.5
VDIFF diff 0 dc 0 ac 1
EP inp cm diff 0 0.5
EN inn cm diff 0 -0.5
XU inp inn out vdd 0 vbn ota7
.control
set noaskquit
set wr_singlescale
set wr_vecnames
op
print v(out) v(xu.n1) v(xu.n2) v(xu.tail) i(vdd)
show m
print @m.xu.m1[vds] @m.xu.m1[vdsat] @m.xu.m2[vds] @m.xu.m2[vdsat]
print @m.xu.m3[vds] @m.xu.m3[vdsat] @m.xu.m4[vds] @m.xu.m4[vdsat]
print @m.xu.m5[vds] @m.xu.m5[vdsat] @m.xu.m6[vds] @m.xu.m6[vdsat] @m.xu.m7[vds] @m.xu.m7[vdsat]
ac dec 100 1 1G
let gain_db = db(v(out))
let phase_deg = 180/PI*cph(v(out))
wrdata ../results/ac.dat gain_db phase_deg
meas ac gain_1hz find gain_db at=1
meas ac ugf when gain_db=0 fall=1
meas ac phase_ugf find phase_deg when gain_db=0 fall=1
dc VDIFF -0.01 0.01 0.00001
wrdata ../results/dc.dat v(out)
quit
.endc
.end
