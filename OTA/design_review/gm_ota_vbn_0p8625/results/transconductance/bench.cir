SCL08 uploaded five-transistor OTA, VBN = 0.8625 V
.include "/home/your-user/pdk/scl08/ngspice_models49/mos/tntp49_5v"
.include "/tmp/capsense-gm5.fXS5V7/designs/gm_ota.inc"
.temp 27
.options reltol=1e-6 vntol=1e-9 abstol=1e-13 method=gear maxord=2
VDD vdd 0 5
VBN vbn 0 0.8625
XG sense sp vdd 0 vbn out gm_ota
CL out 0 5p
VSP sp 0 DC 2.5 AC -.5
VSENSE sense 0 DC 2.5 AC .5
VCLAMP out 0 2.5
.control
set wr_singlescale
set wr_vecnames
set numdgt=12
op
wrdata op.dat v(out) v(xg.n1) v(xg.tail) i(vdd) @m.xg.m1[id] @m.xg.m1[gm] @m.xg.m1[gds] @m.xg.m1[vgs] @m.xg.m1[vds] @m.xg.m1[vdsat] @m.xg.m2[id] @m.xg.m2[gm] @m.xg.m2[gds] @m.xg.m2[vgs] @m.xg.m2[vds] @m.xg.m2[vdsat] @m.xg.m3[id] @m.xg.m3[gm] @m.xg.m3[gds] @m.xg.m3[vgs] @m.xg.m3[vds] @m.xg.m3[vdsat] @m.xg.m4[id] @m.xg.m4[gm] @m.xg.m4[gds] @m.xg.m4[vgs] @m.xg.m4[vds] @m.xg.m4[vdsat] @m.xg.m5[id] @m.xg.m5[gm] @m.xg.m5[gds] @m.xg.m5[vgs] @m.xg.m5[vds] @m.xg.m5[vdsat]
ac dec 80 1 100Meg
let gmr=-real(i(vclamp))
let gmi=-imag(i(vclamp))
wrdata gm.dat gmr gmi
dc VSENSE 2.4 2.6 .0005
let idi=v(sense)-2.5
let iout=-i(vclamp)
wrdata gm_transfer.dat idi iout
quit
.endc
.end
