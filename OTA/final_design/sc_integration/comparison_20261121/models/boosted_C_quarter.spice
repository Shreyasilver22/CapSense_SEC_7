* NGSPICE file created from ota_boosted_layout.ext - technology: SCL_CP8D

.subckt ota_boosted_layout INP INN OUTP OUTM VDD VSS IREF VCM NBOOST PBOOST
M1000 a_329600_989500# a_329600_989500# VDD VDD P w=20u l=3.2u
+  ad=90p pd=49u as=-1852.11p ps=1292.72u
M1001 a_218000_989500# IREF VSS VSS N w=11.429u l=3.2u
+  ad=51.4305p pd=31.858u as=925.722p ps=510.432u
M1002 a_213500_636600# IREF VSS VSS N w=11.429u l=3.2u
+  ad=141.431p pd=89.858u as=0p ps=0u
M1003 OUTM a_218000_429300# OUTM OUTM P w=20u l=10u
+  ad=1710p pd=913u as=0p ps=0u
M1004 OUTM a_219600_813800# a_217700_835900# VDD P w=60u l=2.4u
+  ad=0p pd=0u as=450p ps=218u
M1005 a_328000_718000# a_219600_718000# VDD VDD P w=20u l=1.6u
+  ad=90p pd=49u as=-0p ps=0u
M1006 a_253600_912900# IREF VSS VSS N w=20u l=3.2u
+  ad=90p pd=49u as=0p ps=0u
M1007 a_213500_232000# a_218000_429300# VDD VDD P w=40u l=3.2u
+  ad=450p pd=218u as=-0p ps=0u
M1008 OUTP a_218000_230500# a_213500_232000# VDD P w=60u l=2.4u
+  ad=1710p pd=913u as=0p ps=0u
M1009 a_294000_353400# a_218000_989500# VDD VDD P w=40u l=3.2u
+  ad=360p pd=178u as=-0p ps=0u
M1010 a_213500_914400# a_253600_912900# VDD VDD P w=11.429u l=3.2u
+  ad=231.431p pd=129.858u as=-0p ps=0u
M1011 a_255200_636600# a_255200_636600# VDD VDD P w=20u l=1.6u
+  ad=90p pd=49u as=-0p ps=0u
M1012 OUTP a_218000_429300# OUTP OUTP P w=20u l=10u
+  ad=0p pd=0u as=0p ps=0u
M1013 a_213500_813800# a_253600_912900# VDD VDD P w=11.429u l=3.2u
+  ad=231.431p pd=129.858u as=-0p ps=0u
M1014 a_217700_648700# INP a_221200_76200# VSS N w=15u l=2.4u
+  ad=202.5p pd=108u as=495p ps=247u
M1015 OUTP a_218000_429300# OUTP OUTP P w=20u l=10u
+  ad=0p pd=0u as=0p ps=0u
M1016 a_218000_429300# a_213500_353400# a_295600_991000# VSS N w=10u l=2.4u
+  ad=45p pd=29u as=141.431p ps=89.858u
M1017 a_219600_914400# PBOOST a_213500_914400# VDD P w=20u l=1.6u
+  ad=90p pd=49u as=0p ps=0u
M1018 a_255200_813800# a_255200_813800# VSS VSS N w=10u l=1.6u
+  ad=45p pd=29u as=0p ps=0u
M1019 IREF IREF VSS VSS N w=20u l=3.2u
+  ad=90p pd=49u as=0p ps=0u
M1020 a_219600_718000# a_219600_718000# VDD VDD P w=20u l=1.6u
+  ad=90p pd=49u as=-0p ps=0u
M1021 a_218000_989500# a_218000_989500# VDD VDD P w=20u l=3.2u
+  ad=90p pd=49u as=-0p ps=0u
M1022 OUTM a_219600_636600# a_217700_648700# VSS N w=30u l=2.4u
+  ad=207p pd=165u as=0p ps=0u
M1023 OUTP a_218000_429300# OUTP OUTP P w=20u l=10u
+  ad=0p pd=0u as=0p ps=0u
M1024 a_253600_912900# a_253600_912900# VDD VDD P w=20u l=3.2u
+  ad=90p pd=49u as=-0p ps=0u
M1025 VDD a_218000_429300# VDD VDD P w=20u l=10u
+  ad=-0p pd=0u as=-0p ps=0u
M1026 VDD a_218000_429300# VDD VDD P w=20u l=10u
+  ad=-0p pd=0u as=-0p ps=0u
M1027 a_328000_718000# a_294000_76200# a_213500_718000# VSS N w=10u l=1.6u
+  ad=45p pd=29u as=141.431p ps=89.858u
M1028 VSS OUTP a_216400_1058800# VDD P w=40u l=1.6u
+  ad=729p pd=519u as=360p ps=178u
M1029 OUTM a_218000_429300# OUTM OUTM P w=20u l=10u
+  ad=0p pd=0u as=0p ps=0u
M1030 VDD a_218000_429300# VDD VDD P w=20u l=10u
+  ad=-0p pd=0u as=-0p ps=0u
M1031 OUTM a_218000_429300# OUTM OUTM P w=20u l=10u
+  ad=0p pd=0u as=0p ps=0u
M1032 a_217700_835900# a_218000_429300# VDD VDD P w=40u l=3.2u
+  ad=0p pd=0u as=-0p ps=0u
M1033 a_219600_636600# a_255200_636600# VDD VDD P w=20u l=1.6u
+  ad=90p pd=49u as=-0p ps=0u
M1034 a_216400_1058800# a_218000_989500# VDD VDD P w=40u l=3.2u
+  ad=0p pd=0u as=-0p ps=0u
M1035 a_221200_76200# IREF VSS VSS N w=80u l=3.2u
+  ad=0p pd=0u as=0p ps=0u
M1036 OUTM a_218000_429300# OUTM OUTM P w=20u l=10u
+  ad=0p pd=0u as=0p ps=0u
M1037 OUTM a_218000_429300# OUTM OUTM P w=20u l=10u
+  ad=0p pd=0u as=0p ps=0u
M1038 a_219600_813800# a_255200_813800# VSS VSS N w=10u l=1.6u
+  ad=45p pd=29u as=0p ps=0u
M1039 VSS VCM a_213500_353400# VDD P w=40u l=1.6u
+  ad=0p pd=0u as=360p ps=178u
M1040 a_218000_230500# a_219600_914400# VSS VSS N w=10u l=1.6u
+  ad=45p pd=29u as=0p ps=0u
M1041 a_213500_718000# IREF VSS VSS N w=11.429u l=3.2u
+  ad=0p pd=0u as=0p ps=0u
M1042 a_218000_230500# a_213500_232000# a_213500_914400# VDD P w=20u l=1.6u
+  ad=90p pd=49u as=0p ps=0u
M1043 a_294000_76200# INN a_221200_76200# VSS N w=15u l=2.4u
+  ad=202.5p pd=108u as=0p ps=0u
M1044 a_255200_636600# NBOOST a_213500_636600# VSS N w=10u l=1.6u
+  ad=45p pd=29u as=0p ps=0u
M1045 a_218000_429300# a_329600_989500# VDD VDD P w=20u l=3.2u
+  ad=90p pd=49u as=-0p ps=0u
M1046 a_219600_718000# NBOOST a_213500_718000# VSS N w=10u l=1.6u
+  ad=45p pd=29u as=0p ps=0u
M1047 a_295600_991000# IREF VSS VSS N w=11.429u l=3.2u
+  ad=0p pd=0u as=0p ps=0u
M1048 a_213500_353400# a_218000_989500# VDD VDD P w=40u l=3.2u
+  ad=0p pd=0u as=-0p ps=0u
M1049 OUTM a_218000_429300# OUTM OUTM P w=20u l=10u
+  ad=0p pd=0u as=0p ps=0u
M1050 VSS OUTM a_294000_353400# VDD P w=40u l=1.6u
+  ad=0p pd=0u as=0p ps=0u
M1051 a_219600_636600# a_217700_648700# a_213500_636600# VSS N w=10u l=1.6u
+  ad=45p pd=29u as=0p ps=0u
M1052 OUTM a_218000_429300# OUTM OUTM P w=20u l=10u
+  ad=0p pd=0u as=0p ps=0u
M1053 OUTP a_328000_718000# a_294000_76200# VSS N w=30u l=2.4u
+  ad=207p pd=165u as=0p ps=0u
M1054 OUTP a_218000_429300# OUTP OUTP P w=20u l=10u
+  ad=0p pd=0u as=0p ps=0u
M1055 OUTP a_218000_429300# OUTP OUTP P w=20u l=10u
+  ad=0p pd=0u as=0p ps=0u
M1056 OUTP a_218000_429300# OUTP OUTP P w=20u l=10u
+  ad=0p pd=0u as=0p ps=0u
M1057 OUTP a_218000_429300# OUTP OUTP P w=20u l=10u
+  ad=0p pd=0u as=0p ps=0u
M1058 a_219600_914400# a_219600_914400# VSS VSS N w=10u l=1.6u
+  ad=45p pd=29u as=0p ps=0u
M1059 OUTP a_218000_429300# OUTP OUTP P w=20u l=10u
+  ad=0p pd=0u as=0p ps=0u
M1060 VDD a_218000_429300# VDD VDD P w=20u l=10u
+  ad=-0p pd=0u as=-0p ps=0u
M1061 a_329600_989500# a_216400_2012800# a_295600_991000# VSS N w=10u l=2.4u
+  ad=45p pd=29u as=0p ps=0u
M1062 a_255200_813800# PBOOST a_213500_813800# VDD P w=20u l=1.6u
+  ad=90p pd=49u as=0p ps=0u
M1063 OUTM a_218000_429300# OUTM OUTM P w=20u l=10u
+  ad=0p pd=0u as=0p ps=0u
M1064 a_219600_813800# a_217700_835900# a_213500_813800# VDD P w=20u l=1.6u
+  ad=90p pd=49u as=0p ps=0u
C0 a_295600_991000# VDD 0.9675fF
C1 a_219600_813800# a_255200_813800# 0.1925fF
C2 a_213500_353400# a_217700_648700# 0.0975fF
C3 a_217700_835900# a_328000_718000# 0.29fF
C4 a_213500_353400# IREF 0.1925fF
C5 a_219600_813800# NBOOST 0.1925fF
C6 a_218000_989500# OUTM 0.1925fF
C7 a_219600_914400# VSS 0.58fF
C8 a_213500_232000# VCM 0.0975fF
C9 a_294000_353400# OUTP 0.3875fF
C10 a_218000_429300# PBOOST 0.29fF
C11 a_216400_1058800# a_217700_648700# 0.0975fF
C12 a_294000_353400# a_328000_718000# 0.1925fF
C13 a_253600_912900# a_218000_230500# 0.3875fF
C14 a_213500_914400# a_213500_232000# 0.0975fF
C15 a_221200_76200# OUTP 0.0975fF
C16 a_216400_1058800# IREF 0.485fF
C17 a_213500_718000# VDD 1.065fF
C18 a_255200_636600# a_294000_76200# 0.0975fF
C19 a_217700_648700# a_219600_636600# 0.3875fF
C20 a_328000_718000# a_221200_76200# 0.29fF
C21 a_219600_636600# IREF 0.3875fF
C22 INP INN 0.0975fF
C23 a_216400_2012800# a_213500_914400# 0.1925fF
C24 a_217700_648700# VSS 1.355fF
C25 a_329600_989500# a_295600_991000# 0.485fF
C26 a_218000_989500# a_218000_429300# 0.775fF
C27 a_216400_1058800# a_213500_353400# 0.0975fF
C28 VDD VCM 2.9175fF
C29 IREF VSS 3fF
C30 a_213500_914400# VDD 1.425fF
C31 a_217700_835900# a_217700_648700# 0.29fF
C32 a_213500_353400# a_219600_636600# 0.0975fF
C33 a_294000_76200# INP 0.0975fF
C34 a_217700_835900# IREF 0.58fF
C35 a_219600_718000# NBOOST 0.0975fF
C36 a_213500_353400# VSS 1.065fF
C37 a_219600_813800# VCM 0.0975fF
C38 a_218000_989500# OUTP 0.1925fF
C39 a_219600_914400# PBOOST 0.0975fF
C40 a_294000_353400# a_217700_648700# 0.0975fF
C41 a_216400_1058800# a_219600_636600# 0.0975fF
C42 a_218000_989500# a_328000_718000# 0.1925fF
C43 a_213500_353400# a_217700_835900# 0.0975fF
C44 a_253600_912900# a_213500_232000# 0.1925fF
C45 a_213500_914400# a_219600_813800# 0.1925fF
C46 a_294000_353400# IREF 0.485fF
C47 a_255200_636600# VDD 3.1525fF
C48 a_213500_636600# a_294000_76200# 0.0975fF
C49 a_217700_648700# a_221200_76200# 0.29fF
C50 a_218000_429300# NBOOST 0.1925fF
C51 a_221200_76200# IREF 0.0975fF
C52 a_216400_1058800# VSS 1.065fF
C53 a_216400_2012800# a_253600_912900# 0.0975fF
C54 a_219600_636600# VSS 1.355fF
C55 a_216400_1058800# a_217700_835900# 0.1925fF
C56 a_329600_989500# a_213500_914400# 0.1925fF
C57 a_294000_353400# a_213500_353400# 0.0975fF
C58 a_295600_991000# a_218000_429300# 0.29fF
C59 a_253600_912900# VDD 5.92fF
C60 a_218000_230500# a_294000_76200# 0.0975fF
C61 a_217700_835900# a_219600_636600# 0.1925fF
C62 a_219600_718000# a_213500_718000# 0.1925fF
C63 VDD INP 0.0975fF
C64 a_328000_718000# NBOOST 0.3875fF
C65 a_294000_76200# INN 0.0975fF
C66 a_217700_835900# VSS 1.84fF
C67 a_216400_1058800# a_294000_353400# 0.29fF
C68 a_213500_353400# PBOOST 0.29fF
C69 a_253600_912900# a_219600_813800# 0.29fF
C70 a_218000_230500# a_213500_232000# 0.29fF
C71 a_218000_989500# a_217700_648700# 0.0975fF
C72 a_294000_353400# a_219600_636600# 0.0975fF
C73 a_219600_813800# INP 0.0975fF
C74 a_218000_989500# IREF 0.485fF
C75 a_213500_636600# VDD 0.3875fF
C76 a_219600_636600# a_221200_76200# 0.29fF
C77 a_294000_353400# VSS 1.065fF
C78 a_218000_429300# VCM 0.1925fF
C79 a_216400_2012800# a_218000_230500# 0.0975fF
C80 a_221200_76200# VSS 0.58fF
C81 a_216400_1058800# PBOOST 0.1925fF
C82 a_294000_353400# a_217700_835900# 0.1925fF
C83 a_329600_989500# a_253600_912900# 0.0975fF
C84 a_218000_989500# a_213500_353400# 0.29fF
C85 a_218000_429300# a_213500_914400# 0.1925fF
C86 a_295600_991000# a_219600_914400# 0.3875fF
C87 a_218000_230500# VDD 4.3175fF
C88 a_213500_232000# a_294000_76200# 0.0975fF
C89 a_217700_835900# a_221200_76200# 0.29fF
C90 a_213500_718000# a_328000_718000# 0.29fF
C91 a_217700_648700# NBOOST 0.1925fF
C92 VSS PBOOST 1.065fF
C93 IREF NBOOST 0.3875fF
C94 VDD INN 0.0975fF
C95 OUTM INP 0.0975fF
C96 a_213500_813800# VSS 0.3875fF
C97 a_216400_1058800# a_218000_989500# 0.0975fF
C98 a_328000_718000# VCM 0.0975fF
C99 a_217700_835900# PBOOST 0.1925fF
C100 a_253600_912900# a_219600_718000# 0.3875fF
C101 a_218000_230500# a_219600_813800# 0.29fF
C102 a_217700_835900# a_213500_813800# 0.0975fF
C103 a_218000_989500# a_219600_636600# 0.0975fF
C104 a_295600_991000# IREF 0.29fF
C105 a_213500_353400# NBOOST 0.1925fF
C106 a_294000_76200# VDD 0.87fF
C107 a_219600_813800# INN 0.0975fF
C108 a_218000_989500# VSS 0.9675fF
C109 a_294000_353400# PBOOST 0.1925fF
C110 a_218000_429300# a_253600_912900# 0.1925fF
C111 a_295600_991000# a_213500_353400# 0.0975fF
C112 a_213500_914400# a_219600_914400# 0.1925fF
C113 a_218000_989500# a_217700_835900# 0.0975fF
C114 a_329600_989500# a_218000_230500# 0.0975fF
C115 a_213500_232000# VDD 3.305fF
C116 a_216400_1058800# NBOOST 0.1925fF
C117 a_219600_813800# a_294000_76200# 0.29fF
C118 a_328000_718000# a_255200_636600# 0.0975fF
C119 a_213500_718000# a_217700_648700# 0.0975fF
C120 a_213500_718000# IREF 0.3875fF
C121 a_219600_636600# NBOOST 0.1925fF
C122 a_218000_230500# OUTM 0.29fF
C123 a_255200_813800# VSS 0.3875fF
C124 a_294000_353400# a_218000_989500# 0.0975fF
C125 a_217700_648700# VCM 0.0975fF
C126 a_216400_2012800# VDD 0.3875fF
C127 OUTP INP 0.0975fF
C128 VSS NBOOST 1.065fF
C129 OUTM INN 0.0975fF
C130 a_213500_813800# PBOOST 0.0975fF
C131 a_213500_232000# a_219600_813800# 0.29fF
C132 a_217700_835900# a_255200_813800# 0.0975fF
C133 a_253600_912900# a_328000_718000# 0.0975fF
C134 a_328000_718000# INP 0.0975fF
C135 a_217700_835900# NBOOST 0.1925fF
C136 a_295600_991000# VSS 1.065fF
C137 a_213500_353400# VCM 0.0975fF
C138 a_294000_76200# OUTM 0.485fF
C139 a_218000_989500# PBOOST 0.1925fF
C140 a_218000_429300# a_218000_230500# 0.3875fF
C141 a_213500_914400# a_213500_353400# 0.1925fF
C142 a_219600_914400# a_253600_912900# 0.0975fF
C143 a_328000_718000# a_213500_636600# 0.0975fF
C144 a_255200_636600# a_217700_648700# 0.0975fF
C145 a_213500_718000# a_219600_636600# 0.1925fF
C146 a_219600_813800# VDD 3.4475fF
C147 a_294000_353400# NBOOST 0.1925fF
C148 a_255200_636600# IREF 0.0975fF
C149 a_213500_232000# OUTM 0.29fF
C150 a_216400_1058800# VCM 0.1925fF
C151 a_216400_2012800# a_329600_989500# 0.1925fF
C152 a_213500_718000# VSS 1.065fF
C153 a_219600_636600# VCM 0.0975fF
C154 a_218000_230500# OUTP 0.3875fF
C155 a_255200_813800# PBOOST 0.0975fF
C156 a_329600_989500# VDD 4.155fF
C157 a_218000_429300# a_294000_76200# 0.0975fF
C158 a_213500_813800# a_255200_813800# 0.29fF
C159 a_218000_230500# a_328000_718000# 0.1925fF
C160 a_217700_648700# INP 0.0975fF
C161 a_253600_912900# IREF 0.1925fF
C162 VSS VCM 0.0975fF
C163 IREF INP 0.0975fF
C164 OUTP INN 0.0975fF
C165 a_328000_718000# INN 0.0975fF
C166 a_213500_914400# VSS 1.065fF
C167 VDD OUTM 2.425fF
C168 a_217700_835900# VCM 0.0975fF
C169 a_295600_991000# PBOOST 0.0975fF
C170 a_218000_429300# a_213500_232000# 0.29fF
C171 a_213500_914400# a_217700_835900# 0.0975fF
C172 a_253600_912900# a_213500_353400# 0.1925fF
C173 a_219600_914400# a_218000_230500# 0.0975fF
C174 a_294000_76200# OUTP 0.3875fF
C175 a_219600_718000# VDD 3.3475fF
C176 a_255200_636600# a_219600_636600# 0.1925fF
C177 a_328000_718000# a_294000_76200# 0.3875fF
C178 a_217700_648700# a_213500_636600# 0.0975fF
C179 a_218000_989500# NBOOST 0.1925fF
C180 a_213500_636600# IREF 0.0975fF
C181 a_219600_813800# OUTM 0.485fF
C182 a_294000_353400# VCM 0.1925fF
C183 a_216400_2012800# a_218000_429300# 0.1925fF
C184 a_255200_636600# VSS 0.485fF
C185 a_218000_989500# a_295600_991000# 0.3875fF
C186 a_213500_232000# OUTP 0.3875fF
C187 a_218000_230500# a_217700_648700# 0.0975fF
C188 a_213500_232000# a_328000_718000# 0.1925fF
C189 a_218000_429300# VDD 18.76fF
C190 a_219600_636600# INP 0.0975fF
C191 a_218000_230500# IREF 0.3875fF
C192 a_217700_648700# INN 0.0975fF
C193 a_253600_912900# VSS 1.645fF
C194 VSS INP 0.0975fF
C195 IREF INN 0.0975fF
C196 a_213500_914400# PBOOST 0.29fF
C197 a_218000_429300# a_219600_813800# 0.0975fF
C198 a_253600_912900# a_217700_835900# 0.1925fF
C199 a_213500_914400# a_213500_813800# 0.29fF
C200 a_213500_353400# a_218000_230500# 0.29fF
C201 VDD OUTP 3.5875fF
C202 a_217700_835900# INP 0.0975fF
C203 a_328000_718000# VDD 1.7325fF
C204 a_217700_648700# a_294000_76200# 0.3875fF
C205 a_213500_636600# a_219600_636600# 0.1925fF
C206 a_294000_76200# IREF 0.3875fF
C207 a_218000_989500# VCM 0.0975fF
C208 a_216400_2012800# a_219600_914400# 0.3875fF
C209 a_213500_636600# VSS 0.485fF
C210 a_216400_1058800# a_218000_230500# 0.29fF
C211 a_329600_989500# a_218000_429300# 0.29fF
C212 a_219600_813800# OUTP 0.3875fF
C213 a_219600_914400# VDD 0.475fF
C214 a_213500_232000# a_217700_648700# 0.0975fF
C215 a_213500_353400# a_294000_76200# 0.0975fF
C216 a_218000_230500# a_219600_636600# 0.0975fF
C217 a_219600_813800# a_328000_718000# 0.29fF
C218 a_221200_76200# INP 0.0975fF
C219 a_213500_232000# IREF 0.3875fF
C220 a_213500_718000# NBOOST 0.29fF
C221 a_218000_429300# OUTM 24.15fF
C222 a_219600_636600# INN 0.0975fF
C223 a_218000_230500# VSS 1.84fF
C224 a_253600_912900# PBOOST 0.3875fF
C225 a_216400_1058800# a_294000_76200# 0.0975fF
C226 a_213500_353400# a_213500_232000# 0.0975fF
C227 a_213500_914400# a_255200_813800# 0.3875fF
C228 a_218000_230500# a_217700_835900# 0.29fF
C229 a_253600_912900# a_213500_813800# 0.0975fF
C230 a_216400_2012800# IREF 0.0975fF
C231 VSS INN 0.0975fF
C232 a_217700_648700# VDD 0.87fF
C233 a_219600_636600# a_294000_76200# 0.3875fF
C234 VDD IREF 3.0975fF
C235 OUTM OUTP 1.7425fF
C236 a_217700_835900# INN 0.0975fF
C237 a_328000_718000# OUTM 0.485fF
C238 a_216400_2012800# a_213500_353400# 0.0975fF
C239 a_294000_76200# VSS 1.355fF
C240 a_294000_353400# a_218000_230500# 0.29fF
C241 a_329600_989500# a_219600_914400# 0.3875fF
C242 a_216400_1058800# a_213500_232000# 0.29fF
C243 a_295600_991000# a_213500_914400# 0.1925fF
C244 a_213500_353400# VDD 2.4025fF
C245 a_219600_813800# a_217700_648700# 0.29fF
C246 a_217700_835900# a_294000_76200# 0.29fF
C247 a_213500_232000# a_219600_636600# 0.0975fF
C248 a_219600_718000# a_328000_718000# 0.0975fF
C249 a_219600_813800# IREF 0.3875fF
C250 a_255200_636600# NBOOST 0.0975fF
C251 a_216400_2012800# a_216400_1058800# 0.0975fF
C252 a_221200_76200# INN 0.0975fF
C253 a_213500_232000# VSS 1.1625fF
C254 a_218000_429300# OUTP 24.245fF
C255 a_218000_230500# PBOOST 0.3875fF
C256 a_218000_429300# a_328000_718000# 0.1925fF
C257 a_213500_353400# a_219600_813800# 0.0975fF
C258 a_218000_230500# a_213500_813800# 0.0975fF
C259 a_217700_835900# a_213500_232000# 0.29fF
C260 a_253600_912900# a_255200_813800# 0.0975fF
C261 a_216400_1058800# VDD 2.9825fF
C262 a_294000_353400# a_294000_76200# 0.0975fF
C263 a_329600_989500# IREF 0.29fF
C264 a_294000_76200# a_221200_76200# 0.29fF
C265 a_253600_912900# NBOOST 0.0975fF
C266 a_219600_636600# VDD 1.055fF
C267 a_216400_2012800# VSS 0.6775fF
C268 a_217700_648700# OUTM 0.485fF
C269 VDD VSS 5.685fF
C270 OUTM IREF 0.58fF
C271 a_216400_1058800# a_219600_813800# 0.0975fF
C272 a_294000_353400# a_213500_232000# 0.29fF
C273 a_218000_989500# a_218000_230500# 0.1925fF
C274 a_329600_989500# a_213500_353400# 0.0975fF
C275 a_218000_429300# a_219600_914400# 0.0975fF
C276 a_295600_991000# a_253600_912900# 0.0975fF
C277 a_328000_718000# OUTP 0.3875fF
C278 a_217700_835900# VDD 3.5fF
C279 a_219600_813800# a_219600_636600# 0.1925fF
C280 a_213500_718000# a_255200_636600# 0.3875fF
C281 a_219600_718000# IREF 0.1925fF
C282 a_213500_636600# NBOOST 0.0975fF
C283 a_213500_353400# OUTM 0.1925fF
C284 a_216400_2012800# a_294000_353400# 0.0975fF
C285 a_219600_813800# VSS 1.4525fF
C286 a_213500_232000# PBOOST 0.1925fF
C287 a_218000_429300# a_217700_648700# 0.0975fF
C288 a_213500_232000# a_213500_813800# 0.0975fF
C289 a_218000_230500# a_255200_813800# 0.0975fF
C290 a_217700_835900# a_219600_813800# 0.3875fF
C291 a_253600_912900# a_213500_718000# 0.1925fF
C292 a_294000_353400# VDD 2.9825fF
C293 a_218000_989500# a_294000_76200# 0.0975fF
C294 a_218000_429300# IREF 0.6775fF
C295 a_221200_76200# VDD 0.0975fF
C296 a_218000_230500# NBOOST 0.1925fF
C297 a_216400_1058800# OUTM 0.29fF
C298 a_329600_989500# VSS 1.065fF
C299 a_219600_636600# OUTM 0.485fF
C300 a_216400_2012800# PBOOST 0.0975fF
C301 a_218000_429300# a_213500_353400# 0.6775fF
C302 a_295600_991000# a_218000_230500# 0.0975fF
C303 a_213500_914400# a_253600_912900# 0.29fF
C304 a_294000_353400# a_219600_813800# 0.0975fF
C305 a_218000_989500# a_213500_232000# 0.0975fF
C306 a_217700_648700# OUTP 0.3875fF
C307 OUTP IREF 0.58fF
C308 OUTM VSS 0.58fF
C309 VDD PBOOST 3.4525fF
C310 a_219600_813800# a_221200_76200# 0.29fF
C311 a_328000_718000# a_217700_648700# 0.3875fF
C312 a_213500_718000# a_213500_636600# 0.29fF
C313 a_213500_813800# VDD 1.0375fF
C314 a_328000_718000# IREF 0.6775fF
C315 a_294000_76200# NBOOST 0.1925fF
C316 a_217700_835900# OUTM 0.58fF
C317 a_216400_2012800# a_218000_989500# 0.0975fF
C318 a_219600_718000# VSS 0.485fF
C319 a_216400_1058800# a_218000_429300# 0.9675fF
C320 a_213500_353400# OUTP 0.1925fF
C321 a_219600_813800# PBOOST 0.1925fF
C322 a_218000_989500# VDD 9.7175fF
C323 a_218000_429300# a_219600_636600# 0.0975fF
C324 a_213500_232000# a_255200_813800# 0.0975fF
C325 a_213500_813800# a_219600_813800# 0.1925fF
C326 a_213500_353400# a_328000_718000# 0.1925fF
C327 a_213500_232000# NBOOST 0.1925fF
C328 a_294000_353400# OUTM 0.29fF
C329 a_218000_429300# VSS 2.0325fF
C330 a_218000_230500# VCM 0.0975fF
C331 a_221200_76200# OUTM 0.1925fF
C332 a_216400_1058800# OUTP 0.3875fF
C333 a_329600_989500# PBOOST 0.0975fF
C334 a_218000_429300# a_217700_835900# 0.1925fF
C335 a_219600_914400# a_213500_353400# 0.0975fF
C336 a_213500_914400# a_218000_230500# 0.29fF
C337 a_218000_989500# a_219600_813800# 0.0975fF
C338 a_216400_1058800# a_328000_718000# 0.1925fF
C339 a_219600_636600# OUTP 0.3875fF
C340 a_255200_813800# VDD 0.6675fF
C341 a_328000_718000# a_219600_636600# 0.3875fF
C342 a_255200_636600# a_213500_636600# 0.29fF
C343 a_213500_718000# a_294000_76200# 0.0975fF
C344 a_217700_648700# IREF 0.3875fF
C345 VDD NBOOST 1.065fF
C346 OUTP VSS 0.58fF
C347 a_216400_2012800# a_295600_991000# 0.0975fF
C348 a_328000_718000# VSS 1.935fF
C349 a_218000_989500# a_329600_989500# 0.3875fF
C350 a_294000_353400# a_218000_429300# 0.9675fF
C351 a_294000_76200# VCM 0.0975fF
C352 a_217700_835900# OUTP 0.58fF
C353 INN 0 1.025fF
C354 INP 0 0.86fF
C355 VCM 0 13.14fF
C356 NBOOST 0 29.6725fF
C357 PBOOST 0 29.28fF
C358 VSS 0 0.515fF
C359 IREF 0 114.075fF
C360 OUTP 0 1.505fF
C361 OUTM 0 1.175fF
C362 VDD 0 0.845fF
C363 a_221200_76200# 0 15.705fF
C364 a_294000_76200# 0 45.505fF
C365 a_219600_636600# 0 45.335fF
C366 a_213500_636600# 0 11.12fF
C367 a_217700_648700# 0 46.475fF
C368 a_255200_636600# 0 11.5325fF
C369 a_328000_718000# 0 56.605fF
C370 a_213500_718000# 0 20.65fF
C371 a_219600_718000# 0 11.4575fF
C372 a_255200_813800# 0 12.6125fF
C373 a_219600_813800# 0 50.2375fF
C374 a_213500_813800# 0 9.8025fF
C375 a_213500_232000# 0 42.845fF
C376 a_217700_835900# 0 57.655fF
C377 a_218000_230500# 0 57.7625fF
C378 a_213500_353400# 0 41.5875fF
C379 a_253600_912900# 0 34.0625fF
C380 a_219600_914400# 0 13.975fF
C381 a_213500_914400# 0 19.6525fF
C382 a_218000_429300# 0 119.26fF
C383 a_295600_991000# 0 16.2325fF
C384 a_329600_989500# 0 19.2275fF
C385 a_218000_989500# 0 46.265fF
C386 a_790714_1058800# 0 42.75fF $ **FLOATING
C387 a_294000_353400# 0 70.865fF
C388 a_220000_1058800# 0 42.75fF $ **FLOATING
C389 a_216400_1058800# 0 54.515fF
C390 a_1326428_1058800# 0 0.765fF
C391 a_790714_1064800# 0 42.75fF $ **FLOATING
C392 a_755714_1058800# 0 0.765fF
C393 a_220000_1064800# 0 42.75fF $ **FLOATING
C394 a_790714_1070800# 0 42.75fF $ **FLOATING
C395 a_787114_1064800# 0 0.765fF
C396 a_220000_1070800# 0 42.75fF $ **FLOATING
C397 a_216400_1064800# 0 0.765fF
C398 a_1326428_1070800# 0 0.765fF
C399 a_790714_1076800# 0 42.75fF $ **FLOATING
C400 a_755714_1070800# 0 0.765fF
C401 a_220000_1076800# 0 42.75fF $ **FLOATING
C402 a_790714_1082800# 0 42.75fF $ **FLOATING
C403 a_787114_1076800# 0 0.765fF
C404 a_220000_1082800# 0 42.75fF $ **FLOATING
C405 a_216400_1076800# 0 0.765fF
C406 a_1326428_1082800# 0 0.765fF
C407 a_790714_1088800# 0 42.75fF $ **FLOATING
C408 a_755714_1082800# 0 0.765fF
C409 a_220000_1088800# 0 42.75fF $ **FLOATING
C410 a_790714_1094800# 0 42.75fF $ **FLOATING
C411 a_787114_1088800# 0 0.765fF
C412 a_220000_1094800# 0 42.75fF $ **FLOATING
C413 a_216400_1088800# 0 0.765fF
C414 a_1326428_1094800# 0 0.765fF
C415 a_790714_1100800# 0 42.75fF $ **FLOATING
C416 a_755714_1094800# 0 0.765fF
C417 a_220000_1100800# 0 42.75fF $ **FLOATING
C418 a_790714_1106800# 0 42.75fF $ **FLOATING
C419 a_787114_1100800# 0 0.765fF
C420 a_220000_1106800# 0 42.75fF $ **FLOATING
C421 a_216400_1100800# 0 0.765fF
C422 a_1326428_1106800# 0 0.765fF
C423 a_790714_1112800# 0 42.75fF $ **FLOATING
C424 a_755714_1106800# 0 0.765fF
C425 a_220000_1112800# 0 42.75fF $ **FLOATING
C426 a_790714_1118800# 0 42.75fF $ **FLOATING
C427 a_787114_1112800# 0 0.765fF
C428 a_220000_1118800# 0 42.75fF $ **FLOATING
C429 a_216400_1112800# 0 0.765fF
C430 a_1326428_1118800# 0 0.765fF
C431 a_790714_1124800# 0 42.75fF $ **FLOATING
C432 a_755714_1118800# 0 0.765fF
C433 a_220000_1124800# 0 42.75fF $ **FLOATING
C434 a_790714_1130800# 0 42.75fF $ **FLOATING
C435 a_787114_1124800# 0 0.765fF
C436 a_220000_1130800# 0 42.75fF $ **FLOATING
C437 a_216400_1124800# 0 0.765fF
C438 a_1326428_1130800# 0 0.765fF
C439 a_790714_1136800# 0 42.75fF $ **FLOATING
C440 a_755714_1130800# 0 0.765fF
C441 a_220000_1136800# 0 42.75fF $ **FLOATING
C442 a_790714_1142800# 0 42.75fF $ **FLOATING
C443 a_787114_1136800# 0 0.765fF
C444 a_220000_1142800# 0 42.75fF $ **FLOATING
C445 a_216400_1136800# 0 0.765fF
C446 a_1326428_1142800# 0 0.765fF
C447 a_790714_1148800# 0 42.75fF $ **FLOATING
C448 a_755714_1142800# 0 0.765fF
C449 a_220000_1148800# 0 42.75fF $ **FLOATING
C450 a_790714_1154800# 0 42.75fF $ **FLOATING
C451 a_787114_1148800# 0 0.765fF
C452 a_220000_1154800# 0 42.75fF $ **FLOATING
C453 a_216400_1148800# 0 0.765fF
C454 a_1326428_1154800# 0 0.765fF
C455 a_790714_1160800# 0 42.75fF $ **FLOATING
C456 a_755714_1154800# 0 0.765fF
C457 a_220000_1160800# 0 42.75fF $ **FLOATING
C458 a_790714_1166800# 0 42.75fF $ **FLOATING
C459 a_787114_1160800# 0 0.765fF
C460 a_220000_1166800# 0 42.75fF $ **FLOATING
C461 a_216400_1160800# 0 0.765fF
C462 a_1326428_1166800# 0 0.765fF
C463 a_790714_1172800# 0 42.75fF $ **FLOATING
C464 a_755714_1166800# 0 0.765fF
C465 a_220000_1172800# 0 42.75fF $ **FLOATING
C466 a_790714_1178800# 0 42.75fF $ **FLOATING
C467 a_787114_1172800# 0 0.765fF
C468 a_220000_1178800# 0 42.75fF $ **FLOATING
C469 a_216400_1172800# 0 0.765fF
C470 a_1326428_1178800# 0 0.765fF
C471 a_790714_1184800# 0 42.75fF $ **FLOATING
C472 a_755714_1178800# 0 0.765fF
C473 a_220000_1184800# 0 42.75fF $ **FLOATING
C474 a_790714_1190800# 0 42.75fF $ **FLOATING
C475 a_787114_1184800# 0 0.765fF
C476 a_220000_1190800# 0 42.75fF $ **FLOATING
C477 a_216400_1184800# 0 0.765fF
C478 a_1326428_1190800# 0 0.765fF
C479 a_790714_1196800# 0 42.75fF $ **FLOATING
C480 a_755714_1190800# 0 0.765fF
C481 a_220000_1196800# 0 42.75fF $ **FLOATING
C482 a_790714_1202800# 0 42.75fF $ **FLOATING
C483 a_787114_1196800# 0 0.765fF
C484 a_220000_1202800# 0 42.75fF $ **FLOATING
C485 a_216400_1196800# 0 0.765fF
C486 a_1326428_1202800# 0 0.765fF
C487 a_790714_1208800# 0 42.75fF $ **FLOATING
C488 a_755714_1202800# 0 0.765fF
C489 a_220000_1208800# 0 42.75fF $ **FLOATING
C490 a_790714_1214800# 0 42.75fF $ **FLOATING
C491 a_787114_1208800# 0 0.765fF
C492 a_220000_1214800# 0 42.75fF $ **FLOATING
C493 a_216400_1208800# 0 0.765fF
C494 a_1326428_1214800# 0 0.765fF
C495 a_790714_1220800# 0 42.75fF $ **FLOATING
C496 a_755714_1214800# 0 0.765fF
C497 a_220000_1220800# 0 42.75fF $ **FLOATING
C498 a_790714_1226800# 0 42.75fF $ **FLOATING
C499 a_787114_1220800# 0 0.765fF
C500 a_220000_1226800# 0 42.75fF $ **FLOATING
C501 a_216400_1220800# 0 0.765fF
C502 a_1326428_1226800# 0 0.765fF
C503 a_790714_1232800# 0 42.75fF $ **FLOATING
C504 a_755714_1226800# 0 0.765fF
C505 a_220000_1232800# 0 42.75fF $ **FLOATING
C506 a_790714_1238800# 0 42.75fF $ **FLOATING
C507 a_787114_1232800# 0 0.765fF
C508 a_220000_1238800# 0 42.75fF $ **FLOATING
C509 a_216400_1232800# 0 0.765fF
C510 a_1326428_1238800# 0 0.765fF
C511 a_790714_1244800# 0 42.75fF $ **FLOATING
C512 a_755714_1238800# 0 0.765fF
C513 a_220000_1244800# 0 42.75fF $ **FLOATING
C514 a_790714_1250800# 0 42.75fF $ **FLOATING
C515 a_787114_1244800# 0 0.765fF
C516 a_220000_1250800# 0 42.75fF $ **FLOATING
C517 a_216400_1244800# 0 0.765fF
C518 a_1326428_1250800# 0 0.765fF
C519 a_790714_1256800# 0 42.75fF $ **FLOATING
C520 a_755714_1250800# 0 0.765fF
C521 a_220000_1256800# 0 42.75fF $ **FLOATING
C522 a_790714_1262800# 0 42.75fF $ **FLOATING
C523 a_787114_1256800# 0 0.765fF
C524 a_220000_1262800# 0 42.75fF $ **FLOATING
C525 a_216400_1256800# 0 0.765fF
C526 a_1326428_1262800# 0 0.765fF
C527 a_790714_1268800# 0 42.75fF $ **FLOATING
C528 a_755714_1262800# 0 0.765fF
C529 a_220000_1268800# 0 42.75fF $ **FLOATING
C530 a_790714_1274800# 0 42.75fF $ **FLOATING
C531 a_787114_1268800# 0 0.765fF
C532 a_220000_1274800# 0 42.75fF $ **FLOATING
C533 a_216400_1268800# 0 0.765fF
C534 a_1326428_1274800# 0 0.765fF
C535 a_790714_1280800# 0 42.75fF $ **FLOATING
C536 a_755714_1274800# 0 0.765fF
C537 a_220000_1280800# 0 42.75fF $ **FLOATING
C538 a_790714_1286800# 0 42.75fF $ **FLOATING
C539 a_787114_1280800# 0 0.765fF
C540 a_220000_1286800# 0 42.75fF $ **FLOATING
C541 a_216400_1280800# 0 0.765fF
C542 a_1326428_1286800# 0 0.765fF
C543 a_790714_1292800# 0 42.75fF $ **FLOATING
C544 a_755714_1286800# 0 0.765fF
C545 a_220000_1292800# 0 42.75fF $ **FLOATING
C546 a_790714_1298800# 0 42.75fF $ **FLOATING
C547 a_787114_1292800# 0 0.765fF
C548 a_220000_1298800# 0 42.75fF $ **FLOATING
C549 a_216400_1292800# 0 0.765fF
C550 a_1326428_1298800# 0 0.765fF
C551 a_790714_1304800# 0 42.75fF $ **FLOATING
C552 a_755714_1298800# 0 0.765fF
C553 a_220000_1304800# 0 42.75fF $ **FLOATING
C554 a_790714_1310800# 0 42.75fF $ **FLOATING
C555 a_787114_1304800# 0 0.765fF
C556 a_220000_1310800# 0 42.75fF $ **FLOATING
C557 a_216400_1304800# 0 0.765fF
C558 a_1326428_1310800# 0 0.765fF
C559 a_790714_1316800# 0 42.75fF $ **FLOATING
C560 a_755714_1310800# 0 0.765fF
C561 a_220000_1316800# 0 42.75fF $ **FLOATING
C562 a_790714_1322800# 0 42.75fF $ **FLOATING
C563 a_787114_1316800# 0 0.765fF
C564 a_220000_1322800# 0 42.75fF $ **FLOATING
C565 a_216400_1316800# 0 0.765fF
C566 a_1326428_1322800# 0 0.765fF
C567 a_790714_1328800# 0 42.75fF $ **FLOATING
C568 a_755714_1322800# 0 0.765fF
C569 a_220000_1328800# 0 42.75fF $ **FLOATING
C570 a_790714_1334800# 0 42.75fF $ **FLOATING
C571 a_787114_1328800# 0 0.765fF
C572 a_220000_1334800# 0 42.75fF $ **FLOATING
C573 a_216400_1328800# 0 0.765fF
C574 a_1326428_1334800# 0 0.765fF
C575 a_790714_1340800# 0 42.75fF $ **FLOATING
C576 a_755714_1334800# 0 0.765fF
C577 a_220000_1340800# 0 42.75fF $ **FLOATING
C578 a_790714_1346800# 0 42.75fF $ **FLOATING
C579 a_787114_1340800# 0 0.765fF
C580 a_220000_1346800# 0 42.75fF $ **FLOATING
C581 a_216400_1340800# 0 0.765fF
C582 a_1326428_1346800# 0 0.765fF
C583 a_790714_1352800# 0 42.75fF $ **FLOATING
C584 a_755714_1346800# 0 0.765fF
C585 a_220000_1352800# 0 42.75fF $ **FLOATING
C586 a_790714_1358800# 0 42.75fF $ **FLOATING
C587 a_787114_1352800# 0 0.765fF
C588 a_220000_1358800# 0 42.75fF $ **FLOATING
C589 a_216400_1352800# 0 0.765fF
C590 a_1326428_1358800# 0 0.765fF
C591 a_790714_1364800# 0 42.75fF $ **FLOATING
C592 a_755714_1358800# 0 0.765fF
C593 a_220000_1364800# 0 42.75fF $ **FLOATING
C594 a_790714_1370800# 0 42.75fF $ **FLOATING
C595 a_787114_1364800# 0 0.765fF
C596 a_220000_1370800# 0 42.75fF $ **FLOATING
C597 a_216400_1364800# 0 0.765fF
C598 a_1326428_1370800# 0 0.765fF
C599 a_790714_1376800# 0 42.75fF $ **FLOATING
C600 a_755714_1370800# 0 0.765fF
C601 a_220000_1376800# 0 42.75fF $ **FLOATING
C602 a_790714_1382800# 0 42.75fF $ **FLOATING
C603 a_787114_1376800# 0 0.765fF
C604 a_220000_1382800# 0 42.75fF $ **FLOATING
C605 a_216400_1376800# 0 0.765fF
C606 a_1326428_1382800# 0 0.765fF
C607 a_790714_1388800# 0 42.75fF $ **FLOATING
C608 a_755714_1382800# 0 0.765fF
C609 a_220000_1388800# 0 42.75fF $ **FLOATING
C610 a_790714_1394800# 0 42.75fF $ **FLOATING
C611 a_787114_1388800# 0 0.765fF
C612 a_220000_1394800# 0 42.75fF $ **FLOATING
C613 a_216400_1388800# 0 0.765fF
C614 a_1326428_1394800# 0 0.765fF
C615 a_790714_1400800# 0 42.75fF $ **FLOATING
C616 a_755714_1394800# 0 0.765fF
C617 a_220000_1400800# 0 42.75fF $ **FLOATING
C618 a_790714_1406800# 0 42.75fF $ **FLOATING
C619 a_787114_1400800# 0 0.765fF
C620 a_220000_1406800# 0 42.75fF $ **FLOATING
C621 a_216400_1400800# 0 0.765fF
C622 a_1326428_1406800# 0 0.765fF
C623 a_790714_1412800# 0 42.75fF $ **FLOATING
C624 a_755714_1406800# 0 0.765fF
C625 a_220000_1412800# 0 42.75fF $ **FLOATING
C626 a_790714_1418800# 0 42.75fF $ **FLOATING
C627 a_787114_1412800# 0 0.765fF
C628 a_220000_1418800# 0 42.75fF $ **FLOATING
C629 a_216400_1412800# 0 0.765fF
C630 a_1326428_1418800# 0 0.765fF
C631 a_790714_1424800# 0 42.75fF $ **FLOATING
C632 a_755714_1418800# 0 0.765fF
C633 a_220000_1424800# 0 42.75fF $ **FLOATING
C634 a_790714_1430800# 0 42.75fF $ **FLOATING
C635 a_787114_1424800# 0 0.765fF
C636 a_220000_1430800# 0 42.75fF $ **FLOATING
C637 a_216400_1424800# 0 0.765fF
C638 a_1326428_1430800# 0 0.765fF
C639 a_790714_1436800# 0 42.75fF $ **FLOATING
C640 a_755714_1430800# 0 0.765fF
C641 a_220000_1436800# 0 42.75fF $ **FLOATING
C642 a_790714_1442800# 0 42.75fF $ **FLOATING
C643 a_787114_1436800# 0 0.765fF
C644 a_220000_1442800# 0 42.75fF $ **FLOATING
C645 a_216400_1436800# 0 0.765fF
C646 a_1326428_1442800# 0 0.765fF
C647 a_790714_1448800# 0 42.75fF $ **FLOATING
C648 a_755714_1442800# 0 0.765fF
C649 a_220000_1448800# 0 42.75fF $ **FLOATING
C650 a_790714_1454800# 0 42.75fF $ **FLOATING
C651 a_787114_1448800# 0 0.765fF
C652 a_220000_1454800# 0 42.75fF $ **FLOATING
C653 a_216400_1448800# 0 0.765fF
C654 a_1326428_1454800# 0 0.765fF
C655 a_790714_1460800# 0 42.75fF $ **FLOATING
C656 a_755714_1454800# 0 0.765fF
C657 a_220000_1460800# 0 42.75fF $ **FLOATING
C658 a_790714_1466800# 0 42.75fF $ **FLOATING
C659 a_787114_1460800# 0 0.765fF
C660 a_220000_1466800# 0 42.75fF $ **FLOATING
C661 a_216400_1460800# 0 0.765fF
C662 a_1326428_1466800# 0 0.765fF
C663 a_790714_1472800# 0 42.75fF $ **FLOATING
C664 a_755714_1466800# 0 0.765fF
C665 a_220000_1472800# 0 42.75fF $ **FLOATING
C666 a_790714_1478800# 0 42.75fF $ **FLOATING
C667 a_787114_1472800# 0 0.765fF
C668 a_220000_1478800# 0 42.75fF $ **FLOATING
C669 a_216400_1472800# 0 0.765fF
C670 a_1326428_1478800# 0 0.765fF
C671 a_790714_1484800# 0 42.75fF $ **FLOATING
C672 a_755714_1478800# 0 0.765fF
C673 a_220000_1484800# 0 42.75fF $ **FLOATING
C674 a_790714_1490800# 0 42.75fF $ **FLOATING
C675 a_787114_1484800# 0 0.765fF
C676 a_220000_1490800# 0 42.75fF $ **FLOATING
C677 a_216400_1484800# 0 0.765fF
C678 a_1326428_1490800# 0 0.765fF
C679 a_790714_1496800# 0 42.75fF $ **FLOATING
C680 a_755714_1490800# 0 0.765fF
C681 a_220000_1496800# 0 42.75fF $ **FLOATING
C682 a_790714_1502800# 0 42.75fF $ **FLOATING
C683 a_787114_1496800# 0 0.765fF
C684 a_220000_1502800# 0 42.75fF $ **FLOATING
C685 a_216400_1496800# 0 0.765fF
C686 a_1326428_1502800# 0 0.765fF
C687 a_790714_1508800# 0 42.75fF $ **FLOATING
C688 a_755714_1502800# 0 0.765fF
C689 a_220000_1508800# 0 42.75fF $ **FLOATING
C690 a_790714_1514800# 0 42.75fF $ **FLOATING
C691 a_787114_1508800# 0 0.765fF
C692 a_220000_1514800# 0 42.75fF $ **FLOATING
C693 a_216400_1508800# 0 0.765fF
C694 a_1326428_1514800# 0 0.765fF
C695 a_790714_1520800# 0 42.75fF $ **FLOATING
C696 a_755714_1514800# 0 0.765fF
C697 a_220000_1520800# 0 42.75fF $ **FLOATING
C698 a_790714_1526800# 0 42.75fF $ **FLOATING
C699 a_787114_1520800# 0 0.765fF
C700 a_220000_1526800# 0 42.75fF $ **FLOATING
C701 a_216400_1520800# 0 0.765fF
C702 a_1326428_1526800# 0 0.765fF
C703 a_790714_1532800# 0 42.75fF $ **FLOATING
C704 a_755714_1526800# 0 0.765fF
C705 a_220000_1532800# 0 42.75fF $ **FLOATING
C706 a_790714_1538800# 0 42.75fF $ **FLOATING
C707 a_787114_1532800# 0 0.765fF
C708 a_220000_1538800# 0 42.75fF $ **FLOATING
C709 a_216400_1532800# 0 0.765fF
C710 a_1326428_1538800# 0 0.765fF
C711 a_790714_1544800# 0 42.75fF $ **FLOATING
C712 a_755714_1538800# 0 0.765fF
C713 a_220000_1544800# 0 42.75fF $ **FLOATING
C714 a_790714_1550800# 0 42.75fF $ **FLOATING
C715 a_787114_1544800# 0 0.765fF
C716 a_220000_1550800# 0 42.75fF $ **FLOATING
C717 a_216400_1544800# 0 0.765fF
C718 a_1326428_1550800# 0 0.765fF
C719 a_790714_1556800# 0 42.75fF $ **FLOATING
C720 a_755714_1550800# 0 0.765fF
C721 a_220000_1556800# 0 42.75fF $ **FLOATING
C722 a_790714_1562800# 0 42.75fF $ **FLOATING
C723 a_787114_1556800# 0 0.765fF
C724 a_220000_1562800# 0 42.75fF $ **FLOATING
C725 a_216400_1556800# 0 0.765fF
C726 a_1326428_1562800# 0 0.765fF
C727 a_790714_1568800# 0 42.75fF $ **FLOATING
C728 a_755714_1562800# 0 0.765fF
C729 a_220000_1568800# 0 42.75fF $ **FLOATING
C730 a_790714_1574800# 0 42.75fF $ **FLOATING
C731 a_787114_1568800# 0 0.765fF
C732 a_220000_1574800# 0 42.75fF $ **FLOATING
C733 a_216400_1568800# 0 0.765fF
C734 a_1326428_1574800# 0 0.765fF
C735 a_790714_1580800# 0 42.75fF $ **FLOATING
C736 a_755714_1574800# 0 0.765fF
C737 a_220000_1580800# 0 42.75fF $ **FLOATING
C738 a_790714_1586800# 0 42.75fF $ **FLOATING
C739 a_787114_1580800# 0 0.765fF
C740 a_220000_1586800# 0 42.75fF $ **FLOATING
C741 a_216400_1580800# 0 0.765fF
C742 a_1326428_1586800# 0 0.765fF
C743 a_790714_1592800# 0 42.75fF $ **FLOATING
C744 a_755714_1586800# 0 0.765fF
C745 a_220000_1592800# 0 42.75fF $ **FLOATING
C746 a_790714_1598800# 0 42.75fF $ **FLOATING
C747 a_787114_1592800# 0 0.765fF
C748 a_220000_1598800# 0 42.75fF $ **FLOATING
C749 a_216400_1592800# 0 0.765fF
C750 a_1326428_1598800# 0 0.765fF
C751 a_790714_1604800# 0 42.75fF $ **FLOATING
C752 a_755714_1598800# 0 0.765fF
C753 a_220000_1604800# 0 42.75fF $ **FLOATING
C754 a_790714_1610800# 0 42.75fF $ **FLOATING
C755 a_787114_1604800# 0 0.765fF
C756 a_220000_1610800# 0 42.75fF $ **FLOATING
C757 a_216400_1604800# 0 0.765fF
C758 a_1326428_1610800# 0 0.765fF
C759 a_790714_1616800# 0 42.75fF $ **FLOATING
C760 a_755714_1610800# 0 0.765fF
C761 a_220000_1616800# 0 42.75fF $ **FLOATING
C762 a_790714_1622800# 0 42.75fF $ **FLOATING
C763 a_787114_1616800# 0 0.765fF
C764 a_220000_1622800# 0 42.75fF $ **FLOATING
C765 a_216400_1616800# 0 0.765fF
C766 a_1326428_1622800# 0 0.765fF
C767 a_790714_1628800# 0 42.75fF $ **FLOATING
C768 a_755714_1622800# 0 0.765fF
C769 a_220000_1628800# 0 42.75fF $ **FLOATING
C770 a_790714_1634800# 0 42.75fF $ **FLOATING
C771 a_787114_1628800# 0 0.765fF
C772 a_220000_1634800# 0 42.75fF $ **FLOATING
C773 a_216400_1628800# 0 0.765fF
C774 a_1326428_1634800# 0 0.765fF
C775 a_790714_1640800# 0 42.75fF $ **FLOATING
C776 a_755714_1634800# 0 0.765fF
C777 a_220000_1640800# 0 42.75fF $ **FLOATING
C778 a_790714_1646800# 0 42.75fF $ **FLOATING
C779 a_787114_1640800# 0 0.765fF
C780 a_220000_1646800# 0 42.75fF $ **FLOATING
C781 a_216400_1640800# 0 0.765fF
C782 a_1326428_1646800# 0 0.765fF
C783 a_790714_1652800# 0 42.75fF $ **FLOATING
C784 a_755714_1646800# 0 0.765fF
C785 a_220000_1652800# 0 42.75fF $ **FLOATING
C786 a_790714_1658800# 0 42.75fF $ **FLOATING
C787 a_787114_1652800# 0 0.765fF
C788 a_220000_1658800# 0 42.75fF $ **FLOATING
C789 a_216400_1652800# 0 0.765fF
C790 a_1326428_1658800# 0 0.765fF
C791 a_790714_1664800# 0 42.75fF $ **FLOATING
C792 a_755714_1658800# 0 0.765fF
C793 a_220000_1664800# 0 42.75fF $ **FLOATING
C794 a_790714_1670800# 0 42.75fF $ **FLOATING
C795 a_787114_1664800# 0 0.765fF
C796 a_220000_1670800# 0 42.75fF $ **FLOATING
C797 a_216400_1664800# 0 0.765fF
C798 a_1326428_1670800# 0 0.765fF
C799 a_790714_1676800# 0 42.75fF $ **FLOATING
C800 a_755714_1670800# 0 0.765fF
C801 a_220000_1676800# 0 42.75fF $ **FLOATING
C802 a_790714_1682800# 0 42.75fF $ **FLOATING
C803 a_787114_1676800# 0 0.765fF
C804 a_220000_1682800# 0 42.75fF $ **FLOATING
C805 a_216400_1676800# 0 0.765fF
C806 a_1326428_1682800# 0 0.765fF
C807 a_790714_1688800# 0 42.75fF $ **FLOATING
C808 a_755714_1682800# 0 0.765fF
C809 a_220000_1688800# 0 42.75fF $ **FLOATING
C810 a_790714_1694800# 0 42.75fF $ **FLOATING
C811 a_787114_1688800# 0 0.765fF
C812 a_220000_1694800# 0 42.75fF $ **FLOATING
C813 a_216400_1688800# 0 0.765fF
C814 a_1326428_1694800# 0 0.765fF
C815 a_790714_1700800# 0 42.75fF $ **FLOATING
C816 a_755714_1694800# 0 0.765fF
C817 a_220000_1700800# 0 42.75fF $ **FLOATING
C818 a_790714_1706800# 0 42.75fF $ **FLOATING
C819 a_787114_1700800# 0 0.765fF
C820 a_220000_1706800# 0 42.75fF $ **FLOATING
C821 a_216400_1700800# 0 0.765fF
C822 a_1326428_1706800# 0 0.765fF
C823 a_790714_1712800# 0 42.75fF $ **FLOATING
C824 a_755714_1706800# 0 0.765fF
C825 a_220000_1712800# 0 42.75fF $ **FLOATING
C826 a_790714_1718800# 0 42.75fF $ **FLOATING
C827 a_787114_1712800# 0 0.765fF
C828 a_220000_1718800# 0 42.75fF $ **FLOATING
C829 a_216400_1712800# 0 0.765fF
C830 a_1326428_1718800# 0 0.765fF
C831 a_790714_1724800# 0 42.75fF $ **FLOATING
C832 a_755714_1718800# 0 0.765fF
C833 a_220000_1724800# 0 42.75fF $ **FLOATING
C834 a_790714_1730800# 0 42.75fF $ **FLOATING
C835 a_787114_1724800# 0 0.765fF
C836 a_220000_1730800# 0 42.75fF $ **FLOATING
C837 a_216400_1724800# 0 0.765fF
C838 a_1326428_1730800# 0 0.765fF
C839 a_790714_1736800# 0 42.75fF $ **FLOATING
C840 a_755714_1730800# 0 0.765fF
C841 a_220000_1736800# 0 42.75fF $ **FLOATING
C842 a_790714_1742800# 0 42.75fF $ **FLOATING
C843 a_787114_1736800# 0 0.765fF
C844 a_220000_1742800# 0 42.75fF $ **FLOATING
C845 a_216400_1736800# 0 0.765fF
C846 a_1326428_1742800# 0 0.765fF
C847 a_790714_1748800# 0 42.75fF $ **FLOATING
C848 a_755714_1742800# 0 0.765fF
C849 a_220000_1748800# 0 42.75fF $ **FLOATING
C850 a_790714_1754800# 0 42.75fF $ **FLOATING
C851 a_787114_1748800# 0 0.765fF
C852 a_220000_1754800# 0 42.75fF $ **FLOATING
C853 a_216400_1748800# 0 0.765fF
C854 a_1326428_1754800# 0 0.765fF
C855 a_790714_1760800# 0 42.75fF $ **FLOATING
C856 a_755714_1754800# 0 0.765fF
C857 a_220000_1760800# 0 42.75fF $ **FLOATING
C858 a_790714_1766800# 0 42.75fF $ **FLOATING
C859 a_787114_1760800# 0 0.765fF
C860 a_220000_1766800# 0 42.75fF $ **FLOATING
C861 a_216400_1760800# 0 0.765fF
C862 a_1326428_1766800# 0 0.765fF
C863 a_790714_1772800# 0 42.75fF $ **FLOATING
C864 a_755714_1766800# 0 0.765fF
C865 a_220000_1772800# 0 42.75fF $ **FLOATING
C866 a_790714_1778800# 0 42.75fF $ **FLOATING
C867 a_787114_1772800# 0 0.765fF
C868 a_220000_1778800# 0 42.75fF $ **FLOATING
C869 a_216400_1772800# 0 0.765fF
C870 a_1326428_1778800# 0 0.765fF
C871 a_790714_1784800# 0 42.75fF $ **FLOATING
C872 a_755714_1778800# 0 0.765fF
C873 a_220000_1784800# 0 42.75fF $ **FLOATING
C874 a_790714_1790800# 0 42.75fF $ **FLOATING
C875 a_787114_1784800# 0 0.765fF
C876 a_220000_1790800# 0 42.75fF $ **FLOATING
C877 a_216400_1784800# 0 0.765fF
C878 a_1326428_1790800# 0 0.765fF
C879 a_790714_1796800# 0 42.75fF $ **FLOATING
C880 a_755714_1790800# 0 0.765fF
C881 a_220000_1796800# 0 42.75fF $ **FLOATING
C882 a_790714_1802800# 0 42.75fF $ **FLOATING
C883 a_787114_1796800# 0 0.765fF
C884 a_220000_1802800# 0 42.75fF $ **FLOATING
C885 a_216400_1796800# 0 0.765fF
C886 a_1326428_1802800# 0 0.765fF
C887 a_790714_1808800# 0 42.75fF $ **FLOATING
C888 a_755714_1802800# 0 0.765fF
C889 a_220000_1808800# 0 42.75fF $ **FLOATING
C890 a_790714_1814800# 0 42.75fF $ **FLOATING
C891 a_787114_1808800# 0 0.765fF
C892 a_220000_1814800# 0 42.75fF $ **FLOATING
C893 a_216400_1808800# 0 0.765fF
C894 a_1326428_1814800# 0 0.765fF
C895 a_790714_1820800# 0 42.75fF $ **FLOATING
C896 a_755714_1814800# 0 0.765fF
C897 a_220000_1820800# 0 42.75fF $ **FLOATING
C898 a_790714_1826800# 0 42.75fF $ **FLOATING
C899 a_787114_1820800# 0 0.765fF
C900 a_220000_1826800# 0 42.75fF $ **FLOATING
C901 a_216400_1820800# 0 0.765fF
C902 a_1326428_1826800# 0 0.765fF
C903 a_790714_1832800# 0 42.75fF $ **FLOATING
C904 a_755714_1826800# 0 0.765fF
C905 a_220000_1832800# 0 42.75fF $ **FLOATING
C906 a_790714_1838800# 0 42.75fF $ **FLOATING
C907 a_787114_1832800# 0 0.765fF
C908 a_220000_1838800# 0 42.75fF $ **FLOATING
C909 a_216400_1832800# 0 0.765fF
C910 a_1326428_1838800# 0 0.765fF
C911 a_790714_1844800# 0 42.75fF $ **FLOATING
C912 a_755714_1838800# 0 0.765fF
C913 a_220000_1844800# 0 42.75fF $ **FLOATING
C914 a_790714_1850800# 0 42.75fF $ **FLOATING
C915 a_787114_1844800# 0 0.765fF
C916 a_220000_1850800# 0 42.75fF $ **FLOATING
C917 a_216400_1844800# 0 0.765fF
C918 a_1326428_1850800# 0 0.765fF
C919 a_790714_1856800# 0 42.75fF $ **FLOATING
C920 a_755714_1850800# 0 0.765fF
C921 a_220000_1856800# 0 42.75fF $ **FLOATING
C922 a_790714_1862800# 0 42.75fF $ **FLOATING
C923 a_787114_1856800# 0 0.765fF
C924 a_220000_1862800# 0 42.75fF $ **FLOATING
C925 a_216400_1856800# 0 0.765fF
C926 a_1326428_1862800# 0 0.765fF
C927 a_790714_1868800# 0 42.75fF $ **FLOATING
C928 a_755714_1862800# 0 0.765fF
C929 a_220000_1868800# 0 42.75fF $ **FLOATING
C930 a_790714_1874800# 0 42.75fF $ **FLOATING
C931 a_787114_1868800# 0 0.765fF
C932 a_220000_1874800# 0 42.75fF $ **FLOATING
C933 a_216400_1868800# 0 0.765fF
C934 a_1326428_1874800# 0 0.765fF
C935 a_790714_1880800# 0 42.75fF $ **FLOATING
C936 a_755714_1874800# 0 0.765fF
C937 a_220000_1880800# 0 42.75fF $ **FLOATING
C938 a_790714_1886800# 0 42.75fF $ **FLOATING
C939 a_787114_1880800# 0 0.765fF
C940 a_220000_1886800# 0 42.75fF $ **FLOATING
C941 a_216400_1880800# 0 0.765fF
C942 a_1326428_1886800# 0 0.765fF
C943 a_790714_1892800# 0 42.75fF $ **FLOATING
C944 a_755714_1886800# 0 0.765fF
C945 a_220000_1892800# 0 42.75fF $ **FLOATING
C946 a_790714_1898800# 0 42.75fF $ **FLOATING
C947 a_787114_1892800# 0 0.765fF
C948 a_220000_1898800# 0 42.75fF $ **FLOATING
C949 a_216400_1892800# 0 0.765fF
C950 a_1326428_1898800# 0 0.765fF
C951 a_790714_1904800# 0 42.75fF $ **FLOATING
C952 a_755714_1898800# 0 0.765fF
C953 a_220000_1904800# 0 42.75fF $ **FLOATING
C954 a_790714_1910800# 0 42.75fF $ **FLOATING
C955 a_787114_1904800# 0 0.765fF
C956 a_220000_1910800# 0 42.75fF $ **FLOATING
C957 a_216400_1904800# 0 0.765fF
C958 a_1326428_1910800# 0 0.765fF
C959 a_790714_1916800# 0 42.75fF $ **FLOATING
C960 a_755714_1910800# 0 0.765fF
C961 a_220000_1916800# 0 42.75fF $ **FLOATING
C962 a_790714_1922800# 0 42.75fF $ **FLOATING
C963 a_787114_1916800# 0 0.765fF
C964 a_220000_1922800# 0 42.75fF $ **FLOATING
C965 a_216400_1916800# 0 0.765fF
C966 a_1326428_1922800# 0 0.765fF
C967 a_790714_1928800# 0 42.75fF $ **FLOATING
C968 a_755714_1922800# 0 0.765fF
C969 a_220000_1928800# 0 42.75fF $ **FLOATING
C970 a_790714_1934800# 0 42.75fF $ **FLOATING
C971 a_787114_1928800# 0 0.765fF
C972 a_220000_1934800# 0 42.75fF $ **FLOATING
C973 a_216400_1928800# 0 0.765fF
C974 a_1326428_1934800# 0 0.765fF
C975 a_790714_1940800# 0 42.75fF $ **FLOATING
C976 a_755714_1934800# 0 0.765fF
C977 a_220000_1940800# 0 42.75fF $ **FLOATING
C978 a_790714_1946800# 0 42.75fF $ **FLOATING
C979 a_787114_1940800# 0 0.765fF
C980 a_220000_1946800# 0 42.75fF $ **FLOATING
C981 a_216400_1940800# 0 0.765fF
C982 a_1326428_1946800# 0 0.765fF
C983 a_790714_1952800# 0 42.75fF $ **FLOATING
C984 a_755714_1946800# 0 0.765fF
C985 a_220000_1952800# 0 42.75fF $ **FLOATING
C986 a_790714_1958800# 0 42.75fF $ **FLOATING
C987 a_787114_1952800# 0 0.765fF
C988 a_220000_1958800# 0 42.75fF $ **FLOATING
C989 a_216400_1952800# 0 0.765fF
C990 a_1326428_1958800# 0 0.765fF
C991 a_790714_1964800# 0 42.75fF $ **FLOATING
C992 a_755714_1958800# 0 0.765fF
C993 a_220000_1964800# 0 42.75fF $ **FLOATING
C994 a_790714_1970800# 0 42.75fF $ **FLOATING
C995 a_787114_1964800# 0 0.765fF
C996 a_220000_1970800# 0 42.75fF $ **FLOATING
C997 a_216400_1964800# 0 0.765fF
C998 a_1326428_1970800# 0 0.765fF
C999 a_790714_1976800# 0 42.75fF $ **FLOATING
C1000 a_755714_1970800# 0 0.765fF
C1001 a_220000_1976800# 0 42.75fF $ **FLOATING
C1002 a_790714_1982800# 0 42.75fF $ **FLOATING
C1003 a_787114_1976800# 0 0.765fF
C1004 a_220000_1982800# 0 42.75fF $ **FLOATING
C1005 a_216400_1976800# 0 0.765fF
C1006 a_1326428_1982800# 0 0.765fF
C1007 a_790714_1988800# 0 42.75fF $ **FLOATING
C1008 a_755714_1982800# 0 0.765fF
C1009 a_220000_1988800# 0 42.75fF $ **FLOATING
C1010 a_790714_1994800# 0 42.75fF $ **FLOATING
C1011 a_787114_1988800# 0 0.765fF
C1012 a_220000_1994800# 0 42.75fF $ **FLOATING
C1013 a_216400_1988800# 0 0.765fF
C1014 a_1326428_1994800# 0 0.765fF
C1015 a_790714_2000800# 0 42.75fF $ **FLOATING
C1016 a_755714_1994800# 0 0.765fF
C1017 a_220000_2000800# 0 42.75fF $ **FLOATING
C1018 a_790714_2006800# 0 42.75fF $ **FLOATING
C1019 a_787114_2000800# 0 0.765fF
C1020 a_220000_2006800# 0 42.75fF $ **FLOATING
C1021 a_216400_2000800# 0 0.765fF
C1022 a_1326428_2006800# 0 0.765fF
C1023 a_790714_2012800# 0 42.75fF $ **FLOATING
C1024 a_755714_2006800# 0 0.765fF
C1025 a_220000_2012800# 0 42.75fF $ **FLOATING
C1026 a_216400_2012800# 0 39.8725fF
XR0A a_294000_353400# a_790714_1058800# RPP W=2.4e-06 L=0.000267857
XR0B a_790714_1058800# a_1326428_1058800# RPP W=2.4e-06 L=0.000267857
XR1A a_216400_1058800# a_220000_1058800# RPP W=2.4e-06 L=0.000267857
XR1B a_220000_1058800# a_755714_1058800# RPP W=2.4e-06 L=0.000267857
XR2A a_787114_1064800# a_790714_1064800# RPP W=2.4e-06 L=0.000267857
XR2B a_790714_1064800# a_1326428_1058800# RPP W=2.4e-06 L=0.000267857
XR3A a_216400_1064800# a_220000_1064800# RPP W=2.4e-06 L=0.000267857
XR3B a_220000_1064800# a_755714_1058800# RPP W=2.4e-06 L=0.000267857
XR4A a_787114_1064800# a_790714_1070800# RPP W=2.4e-06 L=0.000267857
XR4B a_790714_1070800# a_1326428_1070800# RPP W=2.4e-06 L=0.000267857
XR5A a_216400_1064800# a_220000_1070800# RPP W=2.4e-06 L=0.000267857
XR5B a_220000_1070800# a_755714_1070800# RPP W=2.4e-06 L=0.000267857
XR6A a_787114_1076800# a_790714_1076800# RPP W=2.4e-06 L=0.000267857
XR6B a_790714_1076800# a_1326428_1070800# RPP W=2.4e-06 L=0.000267857
XR7A a_216400_1076800# a_220000_1076800# RPP W=2.4e-06 L=0.000267857
XR7B a_220000_1076800# a_755714_1070800# RPP W=2.4e-06 L=0.000267857
XR8A a_787114_1076800# a_790714_1082800# RPP W=2.4e-06 L=0.000267857
XR8B a_790714_1082800# a_1326428_1082800# RPP W=2.4e-06 L=0.000267857
XR9A a_216400_1076800# a_220000_1082800# RPP W=2.4e-06 L=0.000267857
XR9B a_220000_1082800# a_755714_1082800# RPP W=2.4e-06 L=0.000267857
XR10A a_787114_1088800# a_790714_1088800# RPP W=2.4e-06 L=0.000267857
XR10B a_790714_1088800# a_1326428_1082800# RPP W=2.4e-06 L=0.000267857
XR11A a_216400_1088800# a_220000_1088800# RPP W=2.4e-06 L=0.000267857
XR11B a_220000_1088800# a_755714_1082800# RPP W=2.4e-06 L=0.000267857
XR12A a_787114_1088800# a_790714_1094800# RPP W=2.4e-06 L=0.000267857
XR12B a_790714_1094800# a_1326428_1094800# RPP W=2.4e-06 L=0.000267857
XR13A a_216400_1088800# a_220000_1094800# RPP W=2.4e-06 L=0.000267857
XR13B a_220000_1094800# a_755714_1094800# RPP W=2.4e-06 L=0.000267857
XR14A a_787114_1100800# a_790714_1100800# RPP W=2.4e-06 L=0.000267857
XR14B a_790714_1100800# a_1326428_1094800# RPP W=2.4e-06 L=0.000267857
XR15A a_216400_1100800# a_220000_1100800# RPP W=2.4e-06 L=0.000267857
XR15B a_220000_1100800# a_755714_1094800# RPP W=2.4e-06 L=0.000267857
XR16A a_787114_1100800# a_790714_1106800# RPP W=2.4e-06 L=0.000267857
XR16B a_790714_1106800# a_1326428_1106800# RPP W=2.4e-06 L=0.000267857
XR17A a_216400_1100800# a_220000_1106800# RPP W=2.4e-06 L=0.000267857
XR17B a_220000_1106800# a_755714_1106800# RPP W=2.4e-06 L=0.000267857
XR18A a_787114_1112800# a_790714_1112800# RPP W=2.4e-06 L=0.000267857
XR18B a_790714_1112800# a_1326428_1106800# RPP W=2.4e-06 L=0.000267857
XR19A a_216400_1112800# a_220000_1112800# RPP W=2.4e-06 L=0.000267857
XR19B a_220000_1112800# a_755714_1106800# RPP W=2.4e-06 L=0.000267857
XR20A a_787114_1112800# a_790714_1118800# RPP W=2.4e-06 L=0.000267857
XR20B a_790714_1118800# a_1326428_1118800# RPP W=2.4e-06 L=0.000267857
XR21A a_216400_1112800# a_220000_1118800# RPP W=2.4e-06 L=0.000267857
XR21B a_220000_1118800# a_755714_1118800# RPP W=2.4e-06 L=0.000267857
XR22A a_787114_1124800# a_790714_1124800# RPP W=2.4e-06 L=0.000267857
XR22B a_790714_1124800# a_1326428_1118800# RPP W=2.4e-06 L=0.000267857
XR23A a_216400_1124800# a_220000_1124800# RPP W=2.4e-06 L=0.000267857
XR23B a_220000_1124800# a_755714_1118800# RPP W=2.4e-06 L=0.000267857
XR24A a_787114_1124800# a_790714_1130800# RPP W=2.4e-06 L=0.000267857
XR24B a_790714_1130800# a_1326428_1130800# RPP W=2.4e-06 L=0.000267857
XR25A a_216400_1124800# a_220000_1130800# RPP W=2.4e-06 L=0.000267857
XR25B a_220000_1130800# a_755714_1130800# RPP W=2.4e-06 L=0.000267857
XR26A a_787114_1136800# a_790714_1136800# RPP W=2.4e-06 L=0.000267857
XR26B a_790714_1136800# a_1326428_1130800# RPP W=2.4e-06 L=0.000267857
XR27A a_216400_1136800# a_220000_1136800# RPP W=2.4e-06 L=0.000267857
XR27B a_220000_1136800# a_755714_1130800# RPP W=2.4e-06 L=0.000267857
XR28A a_787114_1136800# a_790714_1142800# RPP W=2.4e-06 L=0.000267857
XR28B a_790714_1142800# a_1326428_1142800# RPP W=2.4e-06 L=0.000267857
XR29A a_216400_1136800# a_220000_1142800# RPP W=2.4e-06 L=0.000267857
XR29B a_220000_1142800# a_755714_1142800# RPP W=2.4e-06 L=0.000267857
XR30A a_787114_1148800# a_790714_1148800# RPP W=2.4e-06 L=0.000267857
XR30B a_790714_1148800# a_1326428_1142800# RPP W=2.4e-06 L=0.000267857
XR31A a_216400_1148800# a_220000_1148800# RPP W=2.4e-06 L=0.000267857
XR31B a_220000_1148800# a_755714_1142800# RPP W=2.4e-06 L=0.000267857
XR32A a_787114_1148800# a_790714_1154800# RPP W=2.4e-06 L=0.000267857
XR32B a_790714_1154800# a_1326428_1154800# RPP W=2.4e-06 L=0.000267857
XR33A a_216400_1148800# a_220000_1154800# RPP W=2.4e-06 L=0.000267857
XR33B a_220000_1154800# a_755714_1154800# RPP W=2.4e-06 L=0.000267857
XR34A a_787114_1160800# a_790714_1160800# RPP W=2.4e-06 L=0.000267857
XR34B a_790714_1160800# a_1326428_1154800# RPP W=2.4e-06 L=0.000267857
XR35A a_216400_1160800# a_220000_1160800# RPP W=2.4e-06 L=0.000267857
XR35B a_220000_1160800# a_755714_1154800# RPP W=2.4e-06 L=0.000267857
XR36A a_787114_1160800# a_790714_1166800# RPP W=2.4e-06 L=0.000267857
XR36B a_790714_1166800# a_1326428_1166800# RPP W=2.4e-06 L=0.000267857
XR37A a_216400_1160800# a_220000_1166800# RPP W=2.4e-06 L=0.000267857
XR37B a_220000_1166800# a_755714_1166800# RPP W=2.4e-06 L=0.000267857
XR38A a_787114_1172800# a_790714_1172800# RPP W=2.4e-06 L=0.000267857
XR38B a_790714_1172800# a_1326428_1166800# RPP W=2.4e-06 L=0.000267857
XR39A a_216400_1172800# a_220000_1172800# RPP W=2.4e-06 L=0.000267857
XR39B a_220000_1172800# a_755714_1166800# RPP W=2.4e-06 L=0.000267857
XR40A a_787114_1172800# a_790714_1178800# RPP W=2.4e-06 L=0.000267857
XR40B a_790714_1178800# a_1326428_1178800# RPP W=2.4e-06 L=0.000267857
XR41A a_216400_1172800# a_220000_1178800# RPP W=2.4e-06 L=0.000267857
XR41B a_220000_1178800# a_755714_1178800# RPP W=2.4e-06 L=0.000267857
XR42A a_787114_1184800# a_790714_1184800# RPP W=2.4e-06 L=0.000267857
XR42B a_790714_1184800# a_1326428_1178800# RPP W=2.4e-06 L=0.000267857
XR43A a_216400_1184800# a_220000_1184800# RPP W=2.4e-06 L=0.000267857
XR43B a_220000_1184800# a_755714_1178800# RPP W=2.4e-06 L=0.000267857
XR44A a_787114_1184800# a_790714_1190800# RPP W=2.4e-06 L=0.000267857
XR44B a_790714_1190800# a_1326428_1190800# RPP W=2.4e-06 L=0.000267857
XR45A a_216400_1184800# a_220000_1190800# RPP W=2.4e-06 L=0.000267857
XR45B a_220000_1190800# a_755714_1190800# RPP W=2.4e-06 L=0.000267857
XR46A a_787114_1196800# a_790714_1196800# RPP W=2.4e-06 L=0.000267857
XR46B a_790714_1196800# a_1326428_1190800# RPP W=2.4e-06 L=0.000267857
XR47A a_216400_1196800# a_220000_1196800# RPP W=2.4e-06 L=0.000267857
XR47B a_220000_1196800# a_755714_1190800# RPP W=2.4e-06 L=0.000267857
XR48A a_787114_1196800# a_790714_1202800# RPP W=2.4e-06 L=0.000267857
XR48B a_790714_1202800# a_1326428_1202800# RPP W=2.4e-06 L=0.000267857
XR49A a_216400_1196800# a_220000_1202800# RPP W=2.4e-06 L=0.000267857
XR49B a_220000_1202800# a_755714_1202800# RPP W=2.4e-06 L=0.000267857
XR50A a_787114_1208800# a_790714_1208800# RPP W=2.4e-06 L=0.000267857
XR50B a_790714_1208800# a_1326428_1202800# RPP W=2.4e-06 L=0.000267857
XR51A a_216400_1208800# a_220000_1208800# RPP W=2.4e-06 L=0.000267857
XR51B a_220000_1208800# a_755714_1202800# RPP W=2.4e-06 L=0.000267857
XR52A a_787114_1208800# a_790714_1214800# RPP W=2.4e-06 L=0.000267857
XR52B a_790714_1214800# a_1326428_1214800# RPP W=2.4e-06 L=0.000267857
XR53A a_216400_1208800# a_220000_1214800# RPP W=2.4e-06 L=0.000267857
XR53B a_220000_1214800# a_755714_1214800# RPP W=2.4e-06 L=0.000267857
XR54A a_787114_1220800# a_790714_1220800# RPP W=2.4e-06 L=0.000267857
XR54B a_790714_1220800# a_1326428_1214800# RPP W=2.4e-06 L=0.000267857
XR55A a_216400_1220800# a_220000_1220800# RPP W=2.4e-06 L=0.000267857
XR55B a_220000_1220800# a_755714_1214800# RPP W=2.4e-06 L=0.000267857
XR56A a_787114_1220800# a_790714_1226800# RPP W=2.4e-06 L=0.000267857
XR56B a_790714_1226800# a_1326428_1226800# RPP W=2.4e-06 L=0.000267857
XR57A a_216400_1220800# a_220000_1226800# RPP W=2.4e-06 L=0.000267857
XR57B a_220000_1226800# a_755714_1226800# RPP W=2.4e-06 L=0.000267857
XR58A a_787114_1232800# a_790714_1232800# RPP W=2.4e-06 L=0.000267857
XR58B a_790714_1232800# a_1326428_1226800# RPP W=2.4e-06 L=0.000267857
XR59A a_216400_1232800# a_220000_1232800# RPP W=2.4e-06 L=0.000267857
XR59B a_220000_1232800# a_755714_1226800# RPP W=2.4e-06 L=0.000267857
XR60A a_787114_1232800# a_790714_1238800# RPP W=2.4e-06 L=0.000267857
XR60B a_790714_1238800# a_1326428_1238800# RPP W=2.4e-06 L=0.000267857
XR61A a_216400_1232800# a_220000_1238800# RPP W=2.4e-06 L=0.000267857
XR61B a_220000_1238800# a_755714_1238800# RPP W=2.4e-06 L=0.000267857
XR62A a_787114_1244800# a_790714_1244800# RPP W=2.4e-06 L=0.000267857
XR62B a_790714_1244800# a_1326428_1238800# RPP W=2.4e-06 L=0.000267857
XR63A a_216400_1244800# a_220000_1244800# RPP W=2.4e-06 L=0.000267857
XR63B a_220000_1244800# a_755714_1238800# RPP W=2.4e-06 L=0.000267857
XR64A a_787114_1244800# a_790714_1250800# RPP W=2.4e-06 L=0.000267857
XR64B a_790714_1250800# a_1326428_1250800# RPP W=2.4e-06 L=0.000267857
XR65A a_216400_1244800# a_220000_1250800# RPP W=2.4e-06 L=0.000267857
XR65B a_220000_1250800# a_755714_1250800# RPP W=2.4e-06 L=0.000267857
XR66A a_787114_1256800# a_790714_1256800# RPP W=2.4e-06 L=0.000267857
XR66B a_790714_1256800# a_1326428_1250800# RPP W=2.4e-06 L=0.000267857
XR67A a_216400_1256800# a_220000_1256800# RPP W=2.4e-06 L=0.000267857
XR67B a_220000_1256800# a_755714_1250800# RPP W=2.4e-06 L=0.000267857
XR68A a_787114_1256800# a_790714_1262800# RPP W=2.4e-06 L=0.000267857
XR68B a_790714_1262800# a_1326428_1262800# RPP W=2.4e-06 L=0.000267857
XR69A a_216400_1256800# a_220000_1262800# RPP W=2.4e-06 L=0.000267857
XR69B a_220000_1262800# a_755714_1262800# RPP W=2.4e-06 L=0.000267857
XR70A a_787114_1268800# a_790714_1268800# RPP W=2.4e-06 L=0.000267857
XR70B a_790714_1268800# a_1326428_1262800# RPP W=2.4e-06 L=0.000267857
XR71A a_216400_1268800# a_220000_1268800# RPP W=2.4e-06 L=0.000267857
XR71B a_220000_1268800# a_755714_1262800# RPP W=2.4e-06 L=0.000267857
XR72A a_787114_1268800# a_790714_1274800# RPP W=2.4e-06 L=0.000267857
XR72B a_790714_1274800# a_1326428_1274800# RPP W=2.4e-06 L=0.000267857
XR73A a_216400_1268800# a_220000_1274800# RPP W=2.4e-06 L=0.000267857
XR73B a_220000_1274800# a_755714_1274800# RPP W=2.4e-06 L=0.000267857
XR74A a_787114_1280800# a_790714_1280800# RPP W=2.4e-06 L=0.000267857
XR74B a_790714_1280800# a_1326428_1274800# RPP W=2.4e-06 L=0.000267857
XR75A a_216400_1280800# a_220000_1280800# RPP W=2.4e-06 L=0.000267857
XR75B a_220000_1280800# a_755714_1274800# RPP W=2.4e-06 L=0.000267857
XR76A a_787114_1280800# a_790714_1286800# RPP W=2.4e-06 L=0.000267857
XR76B a_790714_1286800# a_1326428_1286800# RPP W=2.4e-06 L=0.000267857
XR77A a_216400_1280800# a_220000_1286800# RPP W=2.4e-06 L=0.000267857
XR77B a_220000_1286800# a_755714_1286800# RPP W=2.4e-06 L=0.000267857
XR78A a_787114_1292800# a_790714_1292800# RPP W=2.4e-06 L=0.000267857
XR78B a_790714_1292800# a_1326428_1286800# RPP W=2.4e-06 L=0.000267857
XR79A a_216400_1292800# a_220000_1292800# RPP W=2.4e-06 L=0.000267857
XR79B a_220000_1292800# a_755714_1286800# RPP W=2.4e-06 L=0.000267857
XR80A a_787114_1292800# a_790714_1298800# RPP W=2.4e-06 L=0.000267857
XR80B a_790714_1298800# a_1326428_1298800# RPP W=2.4e-06 L=0.000267857
XR81A a_216400_1292800# a_220000_1298800# RPP W=2.4e-06 L=0.000267857
XR81B a_220000_1298800# a_755714_1298800# RPP W=2.4e-06 L=0.000267857
XR82A a_787114_1304800# a_790714_1304800# RPP W=2.4e-06 L=0.000267857
XR82B a_790714_1304800# a_1326428_1298800# RPP W=2.4e-06 L=0.000267857
XR83A a_216400_1304800# a_220000_1304800# RPP W=2.4e-06 L=0.000267857
XR83B a_220000_1304800# a_755714_1298800# RPP W=2.4e-06 L=0.000267857
XR84A a_787114_1304800# a_790714_1310800# RPP W=2.4e-06 L=0.000267857
XR84B a_790714_1310800# a_1326428_1310800# RPP W=2.4e-06 L=0.000267857
XR85A a_216400_1304800# a_220000_1310800# RPP W=2.4e-06 L=0.000267857
XR85B a_220000_1310800# a_755714_1310800# RPP W=2.4e-06 L=0.000267857
XR86A a_787114_1316800# a_790714_1316800# RPP W=2.4e-06 L=0.000267857
XR86B a_790714_1316800# a_1326428_1310800# RPP W=2.4e-06 L=0.000267857
XR87A a_216400_1316800# a_220000_1316800# RPP W=2.4e-06 L=0.000267857
XR87B a_220000_1316800# a_755714_1310800# RPP W=2.4e-06 L=0.000267857
XR88A a_787114_1316800# a_790714_1322800# RPP W=2.4e-06 L=0.000267857
XR88B a_790714_1322800# a_1326428_1322800# RPP W=2.4e-06 L=0.000267857
XR89A a_216400_1316800# a_220000_1322800# RPP W=2.4e-06 L=0.000267857
XR89B a_220000_1322800# a_755714_1322800# RPP W=2.4e-06 L=0.000267857
XR90A a_787114_1328800# a_790714_1328800# RPP W=2.4e-06 L=0.000267857
XR90B a_790714_1328800# a_1326428_1322800# RPP W=2.4e-06 L=0.000267857
XR91A a_216400_1328800# a_220000_1328800# RPP W=2.4e-06 L=0.000267857
XR91B a_220000_1328800# a_755714_1322800# RPP W=2.4e-06 L=0.000267857
XR92A a_787114_1328800# a_790714_1334800# RPP W=2.4e-06 L=0.000267857
XR92B a_790714_1334800# a_1326428_1334800# RPP W=2.4e-06 L=0.000267857
XR93A a_216400_1328800# a_220000_1334800# RPP W=2.4e-06 L=0.000267857
XR93B a_220000_1334800# a_755714_1334800# RPP W=2.4e-06 L=0.000267857
XR94A a_787114_1340800# a_790714_1340800# RPP W=2.4e-06 L=0.000267857
XR94B a_790714_1340800# a_1326428_1334800# RPP W=2.4e-06 L=0.000267857
XR95A a_216400_1340800# a_220000_1340800# RPP W=2.4e-06 L=0.000267857
XR95B a_220000_1340800# a_755714_1334800# RPP W=2.4e-06 L=0.000267857
XR96A a_787114_1340800# a_790714_1346800# RPP W=2.4e-06 L=0.000267857
XR96B a_790714_1346800# a_1326428_1346800# RPP W=2.4e-06 L=0.000267857
XR97A a_216400_1340800# a_220000_1346800# RPP W=2.4e-06 L=0.000267857
XR97B a_220000_1346800# a_755714_1346800# RPP W=2.4e-06 L=0.000267857
XR98A a_787114_1352800# a_790714_1352800# RPP W=2.4e-06 L=0.000267857
XR98B a_790714_1352800# a_1326428_1346800# RPP W=2.4e-06 L=0.000267857
XR99A a_216400_1352800# a_220000_1352800# RPP W=2.4e-06 L=0.000267857
XR99B a_220000_1352800# a_755714_1346800# RPP W=2.4e-06 L=0.000267857
XR100A a_787114_1352800# a_790714_1358800# RPP W=2.4e-06 L=0.000267857
XR100B a_790714_1358800# a_1326428_1358800# RPP W=2.4e-06 L=0.000267857
XR101A a_216400_1352800# a_220000_1358800# RPP W=2.4e-06 L=0.000267857
XR101B a_220000_1358800# a_755714_1358800# RPP W=2.4e-06 L=0.000267857
XR102A a_787114_1364800# a_790714_1364800# RPP W=2.4e-06 L=0.000267857
XR102B a_790714_1364800# a_1326428_1358800# RPP W=2.4e-06 L=0.000267857
XR103A a_216400_1364800# a_220000_1364800# RPP W=2.4e-06 L=0.000267857
XR103B a_220000_1364800# a_755714_1358800# RPP W=2.4e-06 L=0.000267857
XR104A a_787114_1364800# a_790714_1370800# RPP W=2.4e-06 L=0.000267857
XR104B a_790714_1370800# a_1326428_1370800# RPP W=2.4e-06 L=0.000267857
XR105A a_216400_1364800# a_220000_1370800# RPP W=2.4e-06 L=0.000267857
XR105B a_220000_1370800# a_755714_1370800# RPP W=2.4e-06 L=0.000267857
XR106A a_787114_1376800# a_790714_1376800# RPP W=2.4e-06 L=0.000267857
XR106B a_790714_1376800# a_1326428_1370800# RPP W=2.4e-06 L=0.000267857
XR107A a_216400_1376800# a_220000_1376800# RPP W=2.4e-06 L=0.000267857
XR107B a_220000_1376800# a_755714_1370800# RPP W=2.4e-06 L=0.000267857
XR108A a_787114_1376800# a_790714_1382800# RPP W=2.4e-06 L=0.000267857
XR108B a_790714_1382800# a_1326428_1382800# RPP W=2.4e-06 L=0.000267857
XR109A a_216400_1376800# a_220000_1382800# RPP W=2.4e-06 L=0.000267857
XR109B a_220000_1382800# a_755714_1382800# RPP W=2.4e-06 L=0.000267857
XR110A a_787114_1388800# a_790714_1388800# RPP W=2.4e-06 L=0.000267857
XR110B a_790714_1388800# a_1326428_1382800# RPP W=2.4e-06 L=0.000267857
XR111A a_216400_1388800# a_220000_1388800# RPP W=2.4e-06 L=0.000267857
XR111B a_220000_1388800# a_755714_1382800# RPP W=2.4e-06 L=0.000267857
XR112A a_787114_1388800# a_790714_1394800# RPP W=2.4e-06 L=0.000267857
XR112B a_790714_1394800# a_1326428_1394800# RPP W=2.4e-06 L=0.000267857
XR113A a_216400_1388800# a_220000_1394800# RPP W=2.4e-06 L=0.000267857
XR113B a_220000_1394800# a_755714_1394800# RPP W=2.4e-06 L=0.000267857
XR114A a_787114_1400800# a_790714_1400800# RPP W=2.4e-06 L=0.000267857
XR114B a_790714_1400800# a_1326428_1394800# RPP W=2.4e-06 L=0.000267857
XR115A a_216400_1400800# a_220000_1400800# RPP W=2.4e-06 L=0.000267857
XR115B a_220000_1400800# a_755714_1394800# RPP W=2.4e-06 L=0.000267857
XR116A a_787114_1400800# a_790714_1406800# RPP W=2.4e-06 L=0.000267857
XR116B a_790714_1406800# a_1326428_1406800# RPP W=2.4e-06 L=0.000267857
XR117A a_216400_1400800# a_220000_1406800# RPP W=2.4e-06 L=0.000267857
XR117B a_220000_1406800# a_755714_1406800# RPP W=2.4e-06 L=0.000267857
XR118A a_787114_1412800# a_790714_1412800# RPP W=2.4e-06 L=0.000267857
XR118B a_790714_1412800# a_1326428_1406800# RPP W=2.4e-06 L=0.000267857
XR119A a_216400_1412800# a_220000_1412800# RPP W=2.4e-06 L=0.000267857
XR119B a_220000_1412800# a_755714_1406800# RPP W=2.4e-06 L=0.000267857
XR120A a_787114_1412800# a_790714_1418800# RPP W=2.4e-06 L=0.000267857
XR120B a_790714_1418800# a_1326428_1418800# RPP W=2.4e-06 L=0.000267857
XR121A a_216400_1412800# a_220000_1418800# RPP W=2.4e-06 L=0.000267857
XR121B a_220000_1418800# a_755714_1418800# RPP W=2.4e-06 L=0.000267857
XR122A a_787114_1424800# a_790714_1424800# RPP W=2.4e-06 L=0.000267857
XR122B a_790714_1424800# a_1326428_1418800# RPP W=2.4e-06 L=0.000267857
XR123A a_216400_1424800# a_220000_1424800# RPP W=2.4e-06 L=0.000267857
XR123B a_220000_1424800# a_755714_1418800# RPP W=2.4e-06 L=0.000267857
XR124A a_787114_1424800# a_790714_1430800# RPP W=2.4e-06 L=0.000267857
XR124B a_790714_1430800# a_1326428_1430800# RPP W=2.4e-06 L=0.000267857
XR125A a_216400_1424800# a_220000_1430800# RPP W=2.4e-06 L=0.000267857
XR125B a_220000_1430800# a_755714_1430800# RPP W=2.4e-06 L=0.000267857
XR126A a_787114_1436800# a_790714_1436800# RPP W=2.4e-06 L=0.000267857
XR126B a_790714_1436800# a_1326428_1430800# RPP W=2.4e-06 L=0.000267857
XR127A a_216400_1436800# a_220000_1436800# RPP W=2.4e-06 L=0.000267857
XR127B a_220000_1436800# a_755714_1430800# RPP W=2.4e-06 L=0.000267857
XR128A a_787114_1436800# a_790714_1442800# RPP W=2.4e-06 L=0.000267857
XR128B a_790714_1442800# a_1326428_1442800# RPP W=2.4e-06 L=0.000267857
XR129A a_216400_1436800# a_220000_1442800# RPP W=2.4e-06 L=0.000267857
XR129B a_220000_1442800# a_755714_1442800# RPP W=2.4e-06 L=0.000267857
XR130A a_787114_1448800# a_790714_1448800# RPP W=2.4e-06 L=0.000267857
XR130B a_790714_1448800# a_1326428_1442800# RPP W=2.4e-06 L=0.000267857
XR131A a_216400_1448800# a_220000_1448800# RPP W=2.4e-06 L=0.000267857
XR131B a_220000_1448800# a_755714_1442800# RPP W=2.4e-06 L=0.000267857
XR132A a_787114_1448800# a_790714_1454800# RPP W=2.4e-06 L=0.000267857
XR132B a_790714_1454800# a_1326428_1454800# RPP W=2.4e-06 L=0.000267857
XR133A a_216400_1448800# a_220000_1454800# RPP W=2.4e-06 L=0.000267857
XR133B a_220000_1454800# a_755714_1454800# RPP W=2.4e-06 L=0.000267857
XR134A a_787114_1460800# a_790714_1460800# RPP W=2.4e-06 L=0.000267857
XR134B a_790714_1460800# a_1326428_1454800# RPP W=2.4e-06 L=0.000267857
XR135A a_216400_1460800# a_220000_1460800# RPP W=2.4e-06 L=0.000267857
XR135B a_220000_1460800# a_755714_1454800# RPP W=2.4e-06 L=0.000267857
XR136A a_787114_1460800# a_790714_1466800# RPP W=2.4e-06 L=0.000267857
XR136B a_790714_1466800# a_1326428_1466800# RPP W=2.4e-06 L=0.000267857
XR137A a_216400_1460800# a_220000_1466800# RPP W=2.4e-06 L=0.000267857
XR137B a_220000_1466800# a_755714_1466800# RPP W=2.4e-06 L=0.000267857
XR138A a_787114_1472800# a_790714_1472800# RPP W=2.4e-06 L=0.000267857
XR138B a_790714_1472800# a_1326428_1466800# RPP W=2.4e-06 L=0.000267857
XR139A a_216400_1472800# a_220000_1472800# RPP W=2.4e-06 L=0.000267857
XR139B a_220000_1472800# a_755714_1466800# RPP W=2.4e-06 L=0.000267857
XR140A a_787114_1472800# a_790714_1478800# RPP W=2.4e-06 L=0.000267857
XR140B a_790714_1478800# a_1326428_1478800# RPP W=2.4e-06 L=0.000267857
XR141A a_216400_1472800# a_220000_1478800# RPP W=2.4e-06 L=0.000267857
XR141B a_220000_1478800# a_755714_1478800# RPP W=2.4e-06 L=0.000267857
XR142A a_787114_1484800# a_790714_1484800# RPP W=2.4e-06 L=0.000267857
XR142B a_790714_1484800# a_1326428_1478800# RPP W=2.4e-06 L=0.000267857
XR143A a_216400_1484800# a_220000_1484800# RPP W=2.4e-06 L=0.000267857
XR143B a_220000_1484800# a_755714_1478800# RPP W=2.4e-06 L=0.000267857
XR144A a_787114_1484800# a_790714_1490800# RPP W=2.4e-06 L=0.000267857
XR144B a_790714_1490800# a_1326428_1490800# RPP W=2.4e-06 L=0.000267857
XR145A a_216400_1484800# a_220000_1490800# RPP W=2.4e-06 L=0.000267857
XR145B a_220000_1490800# a_755714_1490800# RPP W=2.4e-06 L=0.000267857
XR146A a_787114_1496800# a_790714_1496800# RPP W=2.4e-06 L=0.000267857
XR146B a_790714_1496800# a_1326428_1490800# RPP W=2.4e-06 L=0.000267857
XR147A a_216400_1496800# a_220000_1496800# RPP W=2.4e-06 L=0.000267857
XR147B a_220000_1496800# a_755714_1490800# RPP W=2.4e-06 L=0.000267857
XR148A a_787114_1496800# a_790714_1502800# RPP W=2.4e-06 L=0.000267857
XR148B a_790714_1502800# a_1326428_1502800# RPP W=2.4e-06 L=0.000267857
XR149A a_216400_1496800# a_220000_1502800# RPP W=2.4e-06 L=0.000267857
XR149B a_220000_1502800# a_755714_1502800# RPP W=2.4e-06 L=0.000267857
XR150A a_787114_1508800# a_790714_1508800# RPP W=2.4e-06 L=0.000267857
XR150B a_790714_1508800# a_1326428_1502800# RPP W=2.4e-06 L=0.000267857
XR151A a_216400_1508800# a_220000_1508800# RPP W=2.4e-06 L=0.000267857
XR151B a_220000_1508800# a_755714_1502800# RPP W=2.4e-06 L=0.000267857
XR152A a_787114_1508800# a_790714_1514800# RPP W=2.4e-06 L=0.000267857
XR152B a_790714_1514800# a_1326428_1514800# RPP W=2.4e-06 L=0.000267857
XR153A a_216400_1508800# a_220000_1514800# RPP W=2.4e-06 L=0.000267857
XR153B a_220000_1514800# a_755714_1514800# RPP W=2.4e-06 L=0.000267857
XR154A a_787114_1520800# a_790714_1520800# RPP W=2.4e-06 L=0.000267857
XR154B a_790714_1520800# a_1326428_1514800# RPP W=2.4e-06 L=0.000267857
XR155A a_216400_1520800# a_220000_1520800# RPP W=2.4e-06 L=0.000267857
XR155B a_220000_1520800# a_755714_1514800# RPP W=2.4e-06 L=0.000267857
XR156A a_787114_1520800# a_790714_1526800# RPP W=2.4e-06 L=0.000267857
XR156B a_790714_1526800# a_1326428_1526800# RPP W=2.4e-06 L=0.000267857
XR157A a_216400_1520800# a_220000_1526800# RPP W=2.4e-06 L=0.000267857
XR157B a_220000_1526800# a_755714_1526800# RPP W=2.4e-06 L=0.000267857
XR158A a_787114_1532800# a_790714_1532800# RPP W=2.4e-06 L=0.000267857
XR158B a_790714_1532800# a_1326428_1526800# RPP W=2.4e-06 L=0.000267857
XR159A a_216400_1532800# a_220000_1532800# RPP W=2.4e-06 L=0.000267857
XR159B a_220000_1532800# a_755714_1526800# RPP W=2.4e-06 L=0.000267857
XR160A a_787114_1532800# a_790714_1538800# RPP W=2.4e-06 L=0.000267857
XR160B a_790714_1538800# a_1326428_1538800# RPP W=2.4e-06 L=0.000267857
XR161A a_216400_1532800# a_220000_1538800# RPP W=2.4e-06 L=0.000267857
XR161B a_220000_1538800# a_755714_1538800# RPP W=2.4e-06 L=0.000267857
XR162A a_787114_1544800# a_790714_1544800# RPP W=2.4e-06 L=0.000267857
XR162B a_790714_1544800# a_1326428_1538800# RPP W=2.4e-06 L=0.000267857
XR163A a_216400_1544800# a_220000_1544800# RPP W=2.4e-06 L=0.000267857
XR163B a_220000_1544800# a_755714_1538800# RPP W=2.4e-06 L=0.000267857
XR164A a_787114_1544800# a_790714_1550800# RPP W=2.4e-06 L=0.000267857
XR164B a_790714_1550800# a_1326428_1550800# RPP W=2.4e-06 L=0.000267857
XR165A a_216400_1544800# a_220000_1550800# RPP W=2.4e-06 L=0.000267857
XR165B a_220000_1550800# a_755714_1550800# RPP W=2.4e-06 L=0.000267857
XR166A a_787114_1556800# a_790714_1556800# RPP W=2.4e-06 L=0.000267857
XR166B a_790714_1556800# a_1326428_1550800# RPP W=2.4e-06 L=0.000267857
XR167A a_216400_1556800# a_220000_1556800# RPP W=2.4e-06 L=0.000267857
XR167B a_220000_1556800# a_755714_1550800# RPP W=2.4e-06 L=0.000267857
XR168A a_787114_1556800# a_790714_1562800# RPP W=2.4e-06 L=0.000267857
XR168B a_790714_1562800# a_1326428_1562800# RPP W=2.4e-06 L=0.000267857
XR169A a_216400_1556800# a_220000_1562800# RPP W=2.4e-06 L=0.000267857
XR169B a_220000_1562800# a_755714_1562800# RPP W=2.4e-06 L=0.000267857
XR170A a_787114_1568800# a_790714_1568800# RPP W=2.4e-06 L=0.000267857
XR170B a_790714_1568800# a_1326428_1562800# RPP W=2.4e-06 L=0.000267857
XR171A a_216400_1568800# a_220000_1568800# RPP W=2.4e-06 L=0.000267857
XR171B a_220000_1568800# a_755714_1562800# RPP W=2.4e-06 L=0.000267857
XR172A a_787114_1568800# a_790714_1574800# RPP W=2.4e-06 L=0.000267857
XR172B a_790714_1574800# a_1326428_1574800# RPP W=2.4e-06 L=0.000267857
XR173A a_216400_1568800# a_220000_1574800# RPP W=2.4e-06 L=0.000267857
XR173B a_220000_1574800# a_755714_1574800# RPP W=2.4e-06 L=0.000267857
XR174A a_787114_1580800# a_790714_1580800# RPP W=2.4e-06 L=0.000267857
XR174B a_790714_1580800# a_1326428_1574800# RPP W=2.4e-06 L=0.000267857
XR175A a_216400_1580800# a_220000_1580800# RPP W=2.4e-06 L=0.000267857
XR175B a_220000_1580800# a_755714_1574800# RPP W=2.4e-06 L=0.000267857
XR176A a_787114_1580800# a_790714_1586800# RPP W=2.4e-06 L=0.000267857
XR176B a_790714_1586800# a_1326428_1586800# RPP W=2.4e-06 L=0.000267857
XR177A a_216400_1580800# a_220000_1586800# RPP W=2.4e-06 L=0.000267857
XR177B a_220000_1586800# a_755714_1586800# RPP W=2.4e-06 L=0.000267857
XR178A a_787114_1592800# a_790714_1592800# RPP W=2.4e-06 L=0.000267857
XR178B a_790714_1592800# a_1326428_1586800# RPP W=2.4e-06 L=0.000267857
XR179A a_216400_1592800# a_220000_1592800# RPP W=2.4e-06 L=0.000267857
XR179B a_220000_1592800# a_755714_1586800# RPP W=2.4e-06 L=0.000267857
XR180A a_787114_1592800# a_790714_1598800# RPP W=2.4e-06 L=0.000267857
XR180B a_790714_1598800# a_1326428_1598800# RPP W=2.4e-06 L=0.000267857
XR181A a_216400_1592800# a_220000_1598800# RPP W=2.4e-06 L=0.000267857
XR181B a_220000_1598800# a_755714_1598800# RPP W=2.4e-06 L=0.000267857
XR182A a_787114_1604800# a_790714_1604800# RPP W=2.4e-06 L=0.000267857
XR182B a_790714_1604800# a_1326428_1598800# RPP W=2.4e-06 L=0.000267857
XR183A a_216400_1604800# a_220000_1604800# RPP W=2.4e-06 L=0.000267857
XR183B a_220000_1604800# a_755714_1598800# RPP W=2.4e-06 L=0.000267857
XR184A a_787114_1604800# a_790714_1610800# RPP W=2.4e-06 L=0.000267857
XR184B a_790714_1610800# a_1326428_1610800# RPP W=2.4e-06 L=0.000267857
XR185A a_216400_1604800# a_220000_1610800# RPP W=2.4e-06 L=0.000267857
XR185B a_220000_1610800# a_755714_1610800# RPP W=2.4e-06 L=0.000267857
XR186A a_787114_1616800# a_790714_1616800# RPP W=2.4e-06 L=0.000267857
XR186B a_790714_1616800# a_1326428_1610800# RPP W=2.4e-06 L=0.000267857
XR187A a_216400_1616800# a_220000_1616800# RPP W=2.4e-06 L=0.000267857
XR187B a_220000_1616800# a_755714_1610800# RPP W=2.4e-06 L=0.000267857
XR188A a_787114_1616800# a_790714_1622800# RPP W=2.4e-06 L=0.000267857
XR188B a_790714_1622800# a_1326428_1622800# RPP W=2.4e-06 L=0.000267857
XR189A a_216400_1616800# a_220000_1622800# RPP W=2.4e-06 L=0.000267857
XR189B a_220000_1622800# a_755714_1622800# RPP W=2.4e-06 L=0.000267857
XR190A a_787114_1628800# a_790714_1628800# RPP W=2.4e-06 L=0.000267857
XR190B a_790714_1628800# a_1326428_1622800# RPP W=2.4e-06 L=0.000267857
XR191A a_216400_1628800# a_220000_1628800# RPP W=2.4e-06 L=0.000267857
XR191B a_220000_1628800# a_755714_1622800# RPP W=2.4e-06 L=0.000267857
XR192A a_787114_1628800# a_790714_1634800# RPP W=2.4e-06 L=0.000267857
XR192B a_790714_1634800# a_1326428_1634800# RPP W=2.4e-06 L=0.000267857
XR193A a_216400_1628800# a_220000_1634800# RPP W=2.4e-06 L=0.000267857
XR193B a_220000_1634800# a_755714_1634800# RPP W=2.4e-06 L=0.000267857
XR194A a_787114_1640800# a_790714_1640800# RPP W=2.4e-06 L=0.000267857
XR194B a_790714_1640800# a_1326428_1634800# RPP W=2.4e-06 L=0.000267857
XR195A a_216400_1640800# a_220000_1640800# RPP W=2.4e-06 L=0.000267857
XR195B a_220000_1640800# a_755714_1634800# RPP W=2.4e-06 L=0.000267857
XR196A a_787114_1640800# a_790714_1646800# RPP W=2.4e-06 L=0.000267857
XR196B a_790714_1646800# a_1326428_1646800# RPP W=2.4e-06 L=0.000267857
XR197A a_216400_1640800# a_220000_1646800# RPP W=2.4e-06 L=0.000267857
XR197B a_220000_1646800# a_755714_1646800# RPP W=2.4e-06 L=0.000267857
XR198A a_787114_1652800# a_790714_1652800# RPP W=2.4e-06 L=0.000267857
XR198B a_790714_1652800# a_1326428_1646800# RPP W=2.4e-06 L=0.000267857
XR199A a_216400_1652800# a_220000_1652800# RPP W=2.4e-06 L=0.000267857
XR199B a_220000_1652800# a_755714_1646800# RPP W=2.4e-06 L=0.000267857
XR200A a_787114_1652800# a_790714_1658800# RPP W=2.4e-06 L=0.000267857
XR200B a_790714_1658800# a_1326428_1658800# RPP W=2.4e-06 L=0.000267857
XR201A a_216400_1652800# a_220000_1658800# RPP W=2.4e-06 L=0.000267857
XR201B a_220000_1658800# a_755714_1658800# RPP W=2.4e-06 L=0.000267857
XR202A a_787114_1664800# a_790714_1664800# RPP W=2.4e-06 L=0.000267857
XR202B a_790714_1664800# a_1326428_1658800# RPP W=2.4e-06 L=0.000267857
XR203A a_216400_1664800# a_220000_1664800# RPP W=2.4e-06 L=0.000267857
XR203B a_220000_1664800# a_755714_1658800# RPP W=2.4e-06 L=0.000267857
XR204A a_787114_1664800# a_790714_1670800# RPP W=2.4e-06 L=0.000267857
XR204B a_790714_1670800# a_1326428_1670800# RPP W=2.4e-06 L=0.000267857
XR205A a_216400_1664800# a_220000_1670800# RPP W=2.4e-06 L=0.000267857
XR205B a_220000_1670800# a_755714_1670800# RPP W=2.4e-06 L=0.000267857
XR206A a_787114_1676800# a_790714_1676800# RPP W=2.4e-06 L=0.000267857
XR206B a_790714_1676800# a_1326428_1670800# RPP W=2.4e-06 L=0.000267857
XR207A a_216400_1676800# a_220000_1676800# RPP W=2.4e-06 L=0.000267857
XR207B a_220000_1676800# a_755714_1670800# RPP W=2.4e-06 L=0.000267857
XR208A a_787114_1676800# a_790714_1682800# RPP W=2.4e-06 L=0.000267857
XR208B a_790714_1682800# a_1326428_1682800# RPP W=2.4e-06 L=0.000267857
XR209A a_216400_1676800# a_220000_1682800# RPP W=2.4e-06 L=0.000267857
XR209B a_220000_1682800# a_755714_1682800# RPP W=2.4e-06 L=0.000267857
XR210A a_787114_1688800# a_790714_1688800# RPP W=2.4e-06 L=0.000267857
XR210B a_790714_1688800# a_1326428_1682800# RPP W=2.4e-06 L=0.000267857
XR211A a_216400_1688800# a_220000_1688800# RPP W=2.4e-06 L=0.000267857
XR211B a_220000_1688800# a_755714_1682800# RPP W=2.4e-06 L=0.000267857
XR212A a_787114_1688800# a_790714_1694800# RPP W=2.4e-06 L=0.000267857
XR212B a_790714_1694800# a_1326428_1694800# RPP W=2.4e-06 L=0.000267857
XR213A a_216400_1688800# a_220000_1694800# RPP W=2.4e-06 L=0.000267857
XR213B a_220000_1694800# a_755714_1694800# RPP W=2.4e-06 L=0.000267857
XR214A a_787114_1700800# a_790714_1700800# RPP W=2.4e-06 L=0.000267857
XR214B a_790714_1700800# a_1326428_1694800# RPP W=2.4e-06 L=0.000267857
XR215A a_216400_1700800# a_220000_1700800# RPP W=2.4e-06 L=0.000267857
XR215B a_220000_1700800# a_755714_1694800# RPP W=2.4e-06 L=0.000267857
XR216A a_787114_1700800# a_790714_1706800# RPP W=2.4e-06 L=0.000267857
XR216B a_790714_1706800# a_1326428_1706800# RPP W=2.4e-06 L=0.000267857
XR217A a_216400_1700800# a_220000_1706800# RPP W=2.4e-06 L=0.000267857
XR217B a_220000_1706800# a_755714_1706800# RPP W=2.4e-06 L=0.000267857
XR218A a_787114_1712800# a_790714_1712800# RPP W=2.4e-06 L=0.000267857
XR218B a_790714_1712800# a_1326428_1706800# RPP W=2.4e-06 L=0.000267857
XR219A a_216400_1712800# a_220000_1712800# RPP W=2.4e-06 L=0.000267857
XR219B a_220000_1712800# a_755714_1706800# RPP W=2.4e-06 L=0.000267857
XR220A a_787114_1712800# a_790714_1718800# RPP W=2.4e-06 L=0.000267857
XR220B a_790714_1718800# a_1326428_1718800# RPP W=2.4e-06 L=0.000267857
XR221A a_216400_1712800# a_220000_1718800# RPP W=2.4e-06 L=0.000267857
XR221B a_220000_1718800# a_755714_1718800# RPP W=2.4e-06 L=0.000267857
XR222A a_787114_1724800# a_790714_1724800# RPP W=2.4e-06 L=0.000267857
XR222B a_790714_1724800# a_1326428_1718800# RPP W=2.4e-06 L=0.000267857
XR223A a_216400_1724800# a_220000_1724800# RPP W=2.4e-06 L=0.000267857
XR223B a_220000_1724800# a_755714_1718800# RPP W=2.4e-06 L=0.000267857
XR224A a_787114_1724800# a_790714_1730800# RPP W=2.4e-06 L=0.000267857
XR224B a_790714_1730800# a_1326428_1730800# RPP W=2.4e-06 L=0.000267857
XR225A a_216400_1724800# a_220000_1730800# RPP W=2.4e-06 L=0.000267857
XR225B a_220000_1730800# a_755714_1730800# RPP W=2.4e-06 L=0.000267857
XR226A a_787114_1736800# a_790714_1736800# RPP W=2.4e-06 L=0.000267857
XR226B a_790714_1736800# a_1326428_1730800# RPP W=2.4e-06 L=0.000267857
XR227A a_216400_1736800# a_220000_1736800# RPP W=2.4e-06 L=0.000267857
XR227B a_220000_1736800# a_755714_1730800# RPP W=2.4e-06 L=0.000267857
XR228A a_787114_1736800# a_790714_1742800# RPP W=2.4e-06 L=0.000267857
XR228B a_790714_1742800# a_1326428_1742800# RPP W=2.4e-06 L=0.000267857
XR229A a_216400_1736800# a_220000_1742800# RPP W=2.4e-06 L=0.000267857
XR229B a_220000_1742800# a_755714_1742800# RPP W=2.4e-06 L=0.000267857
XR230A a_787114_1748800# a_790714_1748800# RPP W=2.4e-06 L=0.000267857
XR230B a_790714_1748800# a_1326428_1742800# RPP W=2.4e-06 L=0.000267857
XR231A a_216400_1748800# a_220000_1748800# RPP W=2.4e-06 L=0.000267857
XR231B a_220000_1748800# a_755714_1742800# RPP W=2.4e-06 L=0.000267857
XR232A a_787114_1748800# a_790714_1754800# RPP W=2.4e-06 L=0.000267857
XR232B a_790714_1754800# a_1326428_1754800# RPP W=2.4e-06 L=0.000267857
XR233A a_216400_1748800# a_220000_1754800# RPP W=2.4e-06 L=0.000267857
XR233B a_220000_1754800# a_755714_1754800# RPP W=2.4e-06 L=0.000267857
XR234A a_787114_1760800# a_790714_1760800# RPP W=2.4e-06 L=0.000267857
XR234B a_790714_1760800# a_1326428_1754800# RPP W=2.4e-06 L=0.000267857
XR235A a_216400_1760800# a_220000_1760800# RPP W=2.4e-06 L=0.000267857
XR235B a_220000_1760800# a_755714_1754800# RPP W=2.4e-06 L=0.000267857
XR236A a_787114_1760800# a_790714_1766800# RPP W=2.4e-06 L=0.000267857
XR236B a_790714_1766800# a_1326428_1766800# RPP W=2.4e-06 L=0.000267857
XR237A a_216400_1760800# a_220000_1766800# RPP W=2.4e-06 L=0.000267857
XR237B a_220000_1766800# a_755714_1766800# RPP W=2.4e-06 L=0.000267857
XR238A a_787114_1772800# a_790714_1772800# RPP W=2.4e-06 L=0.000267857
XR238B a_790714_1772800# a_1326428_1766800# RPP W=2.4e-06 L=0.000267857
XR239A a_216400_1772800# a_220000_1772800# RPP W=2.4e-06 L=0.000267857
XR239B a_220000_1772800# a_755714_1766800# RPP W=2.4e-06 L=0.000267857
XR240A a_787114_1772800# a_790714_1778800# RPP W=2.4e-06 L=0.000267857
XR240B a_790714_1778800# a_1326428_1778800# RPP W=2.4e-06 L=0.000267857
XR241A a_216400_1772800# a_220000_1778800# RPP W=2.4e-06 L=0.000267857
XR241B a_220000_1778800# a_755714_1778800# RPP W=2.4e-06 L=0.000267857
XR242A a_787114_1784800# a_790714_1784800# RPP W=2.4e-06 L=0.000267857
XR242B a_790714_1784800# a_1326428_1778800# RPP W=2.4e-06 L=0.000267857
XR243A a_216400_1784800# a_220000_1784800# RPP W=2.4e-06 L=0.000267857
XR243B a_220000_1784800# a_755714_1778800# RPP W=2.4e-06 L=0.000267857
XR244A a_787114_1784800# a_790714_1790800# RPP W=2.4e-06 L=0.000267857
XR244B a_790714_1790800# a_1326428_1790800# RPP W=2.4e-06 L=0.000267857
XR245A a_216400_1784800# a_220000_1790800# RPP W=2.4e-06 L=0.000267857
XR245B a_220000_1790800# a_755714_1790800# RPP W=2.4e-06 L=0.000267857
XR246A a_787114_1796800# a_790714_1796800# RPP W=2.4e-06 L=0.000267857
XR246B a_790714_1796800# a_1326428_1790800# RPP W=2.4e-06 L=0.000267857
XR247A a_216400_1796800# a_220000_1796800# RPP W=2.4e-06 L=0.000267857
XR247B a_220000_1796800# a_755714_1790800# RPP W=2.4e-06 L=0.000267857
XR248A a_787114_1796800# a_790714_1802800# RPP W=2.4e-06 L=0.000267857
XR248B a_790714_1802800# a_1326428_1802800# RPP W=2.4e-06 L=0.000267857
XR249A a_216400_1796800# a_220000_1802800# RPP W=2.4e-06 L=0.000267857
XR249B a_220000_1802800# a_755714_1802800# RPP W=2.4e-06 L=0.000267857
XR250A a_787114_1808800# a_790714_1808800# RPP W=2.4e-06 L=0.000267857
XR250B a_790714_1808800# a_1326428_1802800# RPP W=2.4e-06 L=0.000267857
XR251A a_216400_1808800# a_220000_1808800# RPP W=2.4e-06 L=0.000267857
XR251B a_220000_1808800# a_755714_1802800# RPP W=2.4e-06 L=0.000267857
XR252A a_787114_1808800# a_790714_1814800# RPP W=2.4e-06 L=0.000267857
XR252B a_790714_1814800# a_1326428_1814800# RPP W=2.4e-06 L=0.000267857
XR253A a_216400_1808800# a_220000_1814800# RPP W=2.4e-06 L=0.000267857
XR253B a_220000_1814800# a_755714_1814800# RPP W=2.4e-06 L=0.000267857
XR254A a_787114_1820800# a_790714_1820800# RPP W=2.4e-06 L=0.000267857
XR254B a_790714_1820800# a_1326428_1814800# RPP W=2.4e-06 L=0.000267857
XR255A a_216400_1820800# a_220000_1820800# RPP W=2.4e-06 L=0.000267857
XR255B a_220000_1820800# a_755714_1814800# RPP W=2.4e-06 L=0.000267857
XR256A a_787114_1820800# a_790714_1826800# RPP W=2.4e-06 L=0.000267857
XR256B a_790714_1826800# a_1326428_1826800# RPP W=2.4e-06 L=0.000267857
XR257A a_216400_1820800# a_220000_1826800# RPP W=2.4e-06 L=0.000267857
XR257B a_220000_1826800# a_755714_1826800# RPP W=2.4e-06 L=0.000267857
XR258A a_787114_1832800# a_790714_1832800# RPP W=2.4e-06 L=0.000267857
XR258B a_790714_1832800# a_1326428_1826800# RPP W=2.4e-06 L=0.000267857
XR259A a_216400_1832800# a_220000_1832800# RPP W=2.4e-06 L=0.000267857
XR259B a_220000_1832800# a_755714_1826800# RPP W=2.4e-06 L=0.000267857
XR260A a_787114_1832800# a_790714_1838800# RPP W=2.4e-06 L=0.000267857
XR260B a_790714_1838800# a_1326428_1838800# RPP W=2.4e-06 L=0.000267857
XR261A a_216400_1832800# a_220000_1838800# RPP W=2.4e-06 L=0.000267857
XR261B a_220000_1838800# a_755714_1838800# RPP W=2.4e-06 L=0.000267857
XR262A a_787114_1844800# a_790714_1844800# RPP W=2.4e-06 L=0.000267857
XR262B a_790714_1844800# a_1326428_1838800# RPP W=2.4e-06 L=0.000267857
XR263A a_216400_1844800# a_220000_1844800# RPP W=2.4e-06 L=0.000267857
XR263B a_220000_1844800# a_755714_1838800# RPP W=2.4e-06 L=0.000267857
XR264A a_787114_1844800# a_790714_1850800# RPP W=2.4e-06 L=0.000267857
XR264B a_790714_1850800# a_1326428_1850800# RPP W=2.4e-06 L=0.000267857
XR265A a_216400_1844800# a_220000_1850800# RPP W=2.4e-06 L=0.000267857
XR265B a_220000_1850800# a_755714_1850800# RPP W=2.4e-06 L=0.000267857
XR266A a_787114_1856800# a_790714_1856800# RPP W=2.4e-06 L=0.000267857
XR266B a_790714_1856800# a_1326428_1850800# RPP W=2.4e-06 L=0.000267857
XR267A a_216400_1856800# a_220000_1856800# RPP W=2.4e-06 L=0.000267857
XR267B a_220000_1856800# a_755714_1850800# RPP W=2.4e-06 L=0.000267857
XR268A a_787114_1856800# a_790714_1862800# RPP W=2.4e-06 L=0.000267857
XR268B a_790714_1862800# a_1326428_1862800# RPP W=2.4e-06 L=0.000267857
XR269A a_216400_1856800# a_220000_1862800# RPP W=2.4e-06 L=0.000267857
XR269B a_220000_1862800# a_755714_1862800# RPP W=2.4e-06 L=0.000267857
XR270A a_787114_1868800# a_790714_1868800# RPP W=2.4e-06 L=0.000267857
XR270B a_790714_1868800# a_1326428_1862800# RPP W=2.4e-06 L=0.000267857
XR271A a_216400_1868800# a_220000_1868800# RPP W=2.4e-06 L=0.000267857
XR271B a_220000_1868800# a_755714_1862800# RPP W=2.4e-06 L=0.000267857
XR272A a_787114_1868800# a_790714_1874800# RPP W=2.4e-06 L=0.000267857
XR272B a_790714_1874800# a_1326428_1874800# RPP W=2.4e-06 L=0.000267857
XR273A a_216400_1868800# a_220000_1874800# RPP W=2.4e-06 L=0.000267857
XR273B a_220000_1874800# a_755714_1874800# RPP W=2.4e-06 L=0.000267857
XR274A a_787114_1880800# a_790714_1880800# RPP W=2.4e-06 L=0.000267857
XR274B a_790714_1880800# a_1326428_1874800# RPP W=2.4e-06 L=0.000267857
XR275A a_216400_1880800# a_220000_1880800# RPP W=2.4e-06 L=0.000267857
XR275B a_220000_1880800# a_755714_1874800# RPP W=2.4e-06 L=0.000267857
XR276A a_787114_1880800# a_790714_1886800# RPP W=2.4e-06 L=0.000267857
XR276B a_790714_1886800# a_1326428_1886800# RPP W=2.4e-06 L=0.000267857
XR277A a_216400_1880800# a_220000_1886800# RPP W=2.4e-06 L=0.000267857
XR277B a_220000_1886800# a_755714_1886800# RPP W=2.4e-06 L=0.000267857
XR278A a_787114_1892800# a_790714_1892800# RPP W=2.4e-06 L=0.000267857
XR278B a_790714_1892800# a_1326428_1886800# RPP W=2.4e-06 L=0.000267857
XR279A a_216400_1892800# a_220000_1892800# RPP W=2.4e-06 L=0.000267857
XR279B a_220000_1892800# a_755714_1886800# RPP W=2.4e-06 L=0.000267857
XR280A a_787114_1892800# a_790714_1898800# RPP W=2.4e-06 L=0.000267857
XR280B a_790714_1898800# a_1326428_1898800# RPP W=2.4e-06 L=0.000267857
XR281A a_216400_1892800# a_220000_1898800# RPP W=2.4e-06 L=0.000267857
XR281B a_220000_1898800# a_755714_1898800# RPP W=2.4e-06 L=0.000267857
XR282A a_787114_1904800# a_790714_1904800# RPP W=2.4e-06 L=0.000267857
XR282B a_790714_1904800# a_1326428_1898800# RPP W=2.4e-06 L=0.000267857
XR283A a_216400_1904800# a_220000_1904800# RPP W=2.4e-06 L=0.000267857
XR283B a_220000_1904800# a_755714_1898800# RPP W=2.4e-06 L=0.000267857
XR284A a_787114_1904800# a_790714_1910800# RPP W=2.4e-06 L=0.000267857
XR284B a_790714_1910800# a_1326428_1910800# RPP W=2.4e-06 L=0.000267857
XR285A a_216400_1904800# a_220000_1910800# RPP W=2.4e-06 L=0.000267857
XR285B a_220000_1910800# a_755714_1910800# RPP W=2.4e-06 L=0.000267857
XR286A a_787114_1916800# a_790714_1916800# RPP W=2.4e-06 L=0.000267857
XR286B a_790714_1916800# a_1326428_1910800# RPP W=2.4e-06 L=0.000267857
XR287A a_216400_1916800# a_220000_1916800# RPP W=2.4e-06 L=0.000267857
XR287B a_220000_1916800# a_755714_1910800# RPP W=2.4e-06 L=0.000267857
XR288A a_787114_1916800# a_790714_1922800# RPP W=2.4e-06 L=0.000267857
XR288B a_790714_1922800# a_1326428_1922800# RPP W=2.4e-06 L=0.000267857
XR289A a_216400_1916800# a_220000_1922800# RPP W=2.4e-06 L=0.000267857
XR289B a_220000_1922800# a_755714_1922800# RPP W=2.4e-06 L=0.000267857
XR290A a_787114_1928800# a_790714_1928800# RPP W=2.4e-06 L=0.000267857
XR290B a_790714_1928800# a_1326428_1922800# RPP W=2.4e-06 L=0.000267857
XR291A a_216400_1928800# a_220000_1928800# RPP W=2.4e-06 L=0.000267857
XR291B a_220000_1928800# a_755714_1922800# RPP W=2.4e-06 L=0.000267857
XR292A a_787114_1928800# a_790714_1934800# RPP W=2.4e-06 L=0.000267857
XR292B a_790714_1934800# a_1326428_1934800# RPP W=2.4e-06 L=0.000267857
XR293A a_216400_1928800# a_220000_1934800# RPP W=2.4e-06 L=0.000267857
XR293B a_220000_1934800# a_755714_1934800# RPP W=2.4e-06 L=0.000267857
XR294A a_787114_1940800# a_790714_1940800# RPP W=2.4e-06 L=0.000267857
XR294B a_790714_1940800# a_1326428_1934800# RPP W=2.4e-06 L=0.000267857
XR295A a_216400_1940800# a_220000_1940800# RPP W=2.4e-06 L=0.000267857
XR295B a_220000_1940800# a_755714_1934800# RPP W=2.4e-06 L=0.000267857
XR296A a_787114_1940800# a_790714_1946800# RPP W=2.4e-06 L=0.000267857
XR296B a_790714_1946800# a_1326428_1946800# RPP W=2.4e-06 L=0.000267857
XR297A a_216400_1940800# a_220000_1946800# RPP W=2.4e-06 L=0.000267857
XR297B a_220000_1946800# a_755714_1946800# RPP W=2.4e-06 L=0.000267857
XR298A a_787114_1952800# a_790714_1952800# RPP W=2.4e-06 L=0.000267857
XR298B a_790714_1952800# a_1326428_1946800# RPP W=2.4e-06 L=0.000267857
XR299A a_216400_1952800# a_220000_1952800# RPP W=2.4e-06 L=0.000267857
XR299B a_220000_1952800# a_755714_1946800# RPP W=2.4e-06 L=0.000267857
XR300A a_787114_1952800# a_790714_1958800# RPP W=2.4e-06 L=0.000267857
XR300B a_790714_1958800# a_1326428_1958800# RPP W=2.4e-06 L=0.000267857
XR301A a_216400_1952800# a_220000_1958800# RPP W=2.4e-06 L=0.000267857
XR301B a_220000_1958800# a_755714_1958800# RPP W=2.4e-06 L=0.000267857
XR302A a_787114_1964800# a_790714_1964800# RPP W=2.4e-06 L=0.000267857
XR302B a_790714_1964800# a_1326428_1958800# RPP W=2.4e-06 L=0.000267857
XR303A a_216400_1964800# a_220000_1964800# RPP W=2.4e-06 L=0.000267857
XR303B a_220000_1964800# a_755714_1958800# RPP W=2.4e-06 L=0.000267857
XR304A a_787114_1964800# a_790714_1970800# RPP W=2.4e-06 L=0.000267857
XR304B a_790714_1970800# a_1326428_1970800# RPP W=2.4e-06 L=0.000267857
XR305A a_216400_1964800# a_220000_1970800# RPP W=2.4e-06 L=0.000267857
XR305B a_220000_1970800# a_755714_1970800# RPP W=2.4e-06 L=0.000267857
XR306A a_787114_1976800# a_790714_1976800# RPP W=2.4e-06 L=0.000267857
XR306B a_790714_1976800# a_1326428_1970800# RPP W=2.4e-06 L=0.000267857
XR307A a_216400_1976800# a_220000_1976800# RPP W=2.4e-06 L=0.000267857
XR307B a_220000_1976800# a_755714_1970800# RPP W=2.4e-06 L=0.000267857
XR308A a_787114_1976800# a_790714_1982800# RPP W=2.4e-06 L=0.000267857
XR308B a_790714_1982800# a_1326428_1982800# RPP W=2.4e-06 L=0.000267857
XR309A a_216400_1976800# a_220000_1982800# RPP W=2.4e-06 L=0.000267857
XR309B a_220000_1982800# a_755714_1982800# RPP W=2.4e-06 L=0.000267857
XR310A a_787114_1988800# a_790714_1988800# RPP W=2.4e-06 L=0.000267857
XR310B a_790714_1988800# a_1326428_1982800# RPP W=2.4e-06 L=0.000267857
XR311A a_216400_1988800# a_220000_1988800# RPP W=2.4e-06 L=0.000267857
XR311B a_220000_1988800# a_755714_1982800# RPP W=2.4e-06 L=0.000267857
XR312A a_787114_1988800# a_790714_1994800# RPP W=2.4e-06 L=0.000267857
XR312B a_790714_1994800# a_1326428_1994800# RPP W=2.4e-06 L=0.000267857
XR313A a_216400_1988800# a_220000_1994800# RPP W=2.4e-06 L=0.000267857
XR313B a_220000_1994800# a_755714_1994800# RPP W=2.4e-06 L=0.000267857
XR314A a_787114_2000800# a_790714_2000800# RPP W=2.4e-06 L=0.000267857
XR314B a_790714_2000800# a_1326428_1994800# RPP W=2.4e-06 L=0.000267857
XR315A a_216400_2000800# a_220000_2000800# RPP W=2.4e-06 L=0.000267857
XR315B a_220000_2000800# a_755714_1994800# RPP W=2.4e-06 L=0.000267857
XR316A a_787114_2000800# a_790714_2006800# RPP W=2.4e-06 L=0.000267857
XR316B a_790714_2006800# a_1326428_2006800# RPP W=2.4e-06 L=0.000267857
XR317A a_216400_2000800# a_220000_2006800# RPP W=2.4e-06 L=0.000267857
XR317B a_220000_2006800# a_755714_2006800# RPP W=2.4e-06 L=0.000267857
XR318A a_216400_2012800# a_790714_2012800# RPP W=2.4e-06 L=0.000267857
XR318B a_790714_2012800# a_1326428_2006800# RPP W=2.4e-06 L=0.000267857
XR319A a_216400_2012800# a_220000_2012800# RPP W=2.4e-06 L=0.000267857
XR319B a_220000_2012800# a_755714_2006800# RPP W=2.4e-06 L=0.000267857
.ends
