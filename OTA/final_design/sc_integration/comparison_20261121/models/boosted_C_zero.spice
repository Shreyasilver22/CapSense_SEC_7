* NGSPICE file created from ota_boosted_layout.ext - technology: SCL_CP8D

.subckt ota_boosted_layout INP INN OUTP OUTM VDD VSS IREF VCM NBOOST PBOOST
M1000 a_329600_989500# a_329600_989500# VDD VDD P w=20u l=3.2u
+  ad=90p pd=49u as=-1852.11p ps=1292.72u
M1001 a_218000_989500# IREF VSS VSS N w=11.429u l=3.2u
+  ad=51.4305p pd=31.858u as=925.722p ps=510.432u
M1002 a_213500_636600# IREF VSS VSS N w=11.429u l=3.2u
+  ad=141.431p pd=89.858u as=0p ps=0u
M1003 OUTM a_218000_429300# OUTM OUTM P w=20u l=10u
+  ad=1710p pd=913u as=0p ps=0u
M1004 OUTM a_219600_813800# a_217700_835900# VDD P w=60u l=2.4u
+  ad=0p pd=0u as=450p ps=218u
M1005 a_328000_718000# a_219600_718000# VDD VDD P w=20u l=1.6u
+  ad=90p pd=49u as=-0p ps=0u
M1006 a_253600_912900# IREF VSS VSS N w=20u l=3.2u
+  ad=90p pd=49u as=0p ps=0u
M1007 a_213500_232000# a_218000_429300# VDD VDD P w=40u l=3.2u
+  ad=450p pd=218u as=-0p ps=0u
M1008 OUTP a_218000_230500# a_213500_232000# VDD P w=60u l=2.4u
+  ad=1710p pd=913u as=0p ps=0u
M1009 a_294000_353400# a_218000_989500# VDD VDD P w=40u l=3.2u
+  ad=360p pd=178u as=-0p ps=0u
M1010 a_213500_914400# a_253600_912900# VDD VDD P w=11.429u l=3.2u
+  ad=231.431p pd=129.858u as=-0p ps=0u
M1011 a_255200_636600# a_255200_636600# VDD VDD P w=20u l=1.6u
+  ad=90p pd=49u as=-0p ps=0u
M1012 OUTP a_218000_429300# OUTP OUTP P w=20u l=10u
+  ad=0p pd=0u as=0p ps=0u
M1013 a_213500_813800# a_253600_912900# VDD VDD P w=11.429u l=3.2u
+  ad=231.431p pd=129.858u as=-0p ps=0u
M1014 a_217700_648700# INP a_221200_76200# VSS N w=15u l=2.4u
+  ad=202.5p pd=108u as=495p ps=247u
M1015 OUTP a_218000_429300# OUTP OUTP P w=20u l=10u
+  ad=0p pd=0u as=0p ps=0u
M1016 a_218000_429300# a_213500_353400# a_295600_991000# VSS N w=10u l=2.4u
+  ad=45p pd=29u as=141.431p ps=89.858u
M1017 a_219600_914400# PBOOST a_213500_914400# VDD P w=20u l=1.6u
+  ad=90p pd=49u as=0p ps=0u
M1018 a_255200_813800# a_255200_813800# VSS VSS N w=10u l=1.6u
+  ad=45p pd=29u as=0p ps=0u
M1019 IREF IREF VSS VSS N w=20u l=3.2u
+  ad=90p pd=49u as=0p ps=0u
M1020 a_219600_718000# a_219600_718000# VDD VDD P w=20u l=1.6u
+  ad=90p pd=49u as=-0p ps=0u
M1021 a_218000_989500# a_218000_989500# VDD VDD P w=20u l=3.2u
+  ad=90p pd=49u as=-0p ps=0u
M1022 OUTM a_219600_636600# a_217700_648700# VSS N w=30u l=2.4u
+  ad=207p pd=165u as=0p ps=0u
M1023 OUTP a_218000_429300# OUTP OUTP P w=20u l=10u
+  ad=0p pd=0u as=0p ps=0u
M1024 a_253600_912900# a_253600_912900# VDD VDD P w=20u l=3.2u
+  ad=90p pd=49u as=-0p ps=0u
M1025 VDD a_218000_429300# VDD VDD P w=20u l=10u
+  ad=-0p pd=0u as=-0p ps=0u
M1026 VDD a_218000_429300# VDD VDD P w=20u l=10u
+  ad=-0p pd=0u as=-0p ps=0u
M1027 a_328000_718000# a_294000_76200# a_213500_718000# VSS N w=10u l=1.6u
+  ad=45p pd=29u as=141.431p ps=89.858u
M1028 VSS OUTP a_216400_1058800# VDD P w=40u l=1.6u
+  ad=729p pd=519u as=360p ps=178u
M1029 OUTM a_218000_429300# OUTM OUTM P w=20u l=10u
+  ad=0p pd=0u as=0p ps=0u
M1030 VDD a_218000_429300# VDD VDD P w=20u l=10u
+  ad=-0p pd=0u as=-0p ps=0u
M1031 OUTM a_218000_429300# OUTM OUTM P w=20u l=10u
+  ad=0p pd=0u as=0p ps=0u
M1032 a_217700_835900# a_218000_429300# VDD VDD P w=40u l=3.2u
+  ad=0p pd=0u as=-0p ps=0u
M1033 a_219600_636600# a_255200_636600# VDD VDD P w=20u l=1.6u
+  ad=90p pd=49u as=-0p ps=0u
M1034 a_216400_1058800# a_218000_989500# VDD VDD P w=40u l=3.2u
+  ad=0p pd=0u as=-0p ps=0u
M1035 a_221200_76200# IREF VSS VSS N w=80u l=3.2u
+  ad=0p pd=0u as=0p ps=0u
M1036 OUTM a_218000_429300# OUTM OUTM P w=20u l=10u
+  ad=0p pd=0u as=0p ps=0u
M1037 OUTM a_218000_429300# OUTM OUTM P w=20u l=10u
+  ad=0p pd=0u as=0p ps=0u
M1038 a_219600_813800# a_255200_813800# VSS VSS N w=10u l=1.6u
+  ad=45p pd=29u as=0p ps=0u
M1039 VSS VCM a_213500_353400# VDD P w=40u l=1.6u
+  ad=0p pd=0u as=360p ps=178u
M1040 a_218000_230500# a_219600_914400# VSS VSS N w=10u l=1.6u
+  ad=45p pd=29u as=0p ps=0u
M1041 a_213500_718000# IREF VSS VSS N w=11.429u l=3.2u
+  ad=0p pd=0u as=0p ps=0u
M1042 a_218000_230500# a_213500_232000# a_213500_914400# VDD P w=20u l=1.6u
+  ad=90p pd=49u as=0p ps=0u
M1043 a_294000_76200# INN a_221200_76200# VSS N w=15u l=2.4u
+  ad=202.5p pd=108u as=0p ps=0u
M1044 a_255200_636600# NBOOST a_213500_636600# VSS N w=10u l=1.6u
+  ad=45p pd=29u as=0p ps=0u
M1045 a_218000_429300# a_329600_989500# VDD VDD P w=20u l=3.2u
+  ad=90p pd=49u as=-0p ps=0u
M1046 a_219600_718000# NBOOST a_213500_718000# VSS N w=10u l=1.6u
+  ad=45p pd=29u as=0p ps=0u
M1047 a_295600_991000# IREF VSS VSS N w=11.429u l=3.2u
+  ad=0p pd=0u as=0p ps=0u
M1048 a_213500_353400# a_218000_989500# VDD VDD P w=40u l=3.2u
+  ad=0p pd=0u as=-0p ps=0u
M1049 OUTM a_218000_429300# OUTM OUTM P w=20u l=10u
+  ad=0p pd=0u as=0p ps=0u
M1050 VSS OUTM a_294000_353400# VDD P w=40u l=1.6u
+  ad=0p pd=0u as=0p ps=0u
M1051 a_219600_636600# a_217700_648700# a_213500_636600# VSS N w=10u l=1.6u
+  ad=45p pd=29u as=0p ps=0u
M1052 OUTM a_218000_429300# OUTM OUTM P w=20u l=10u
+  ad=0p pd=0u as=0p ps=0u
M1053 OUTP a_328000_718000# a_294000_76200# VSS N w=30u l=2.4u
+  ad=207p pd=165u as=0p ps=0u
M1054 OUTP a_218000_429300# OUTP OUTP P w=20u l=10u
+  ad=0p pd=0u as=0p ps=0u
M1055 OUTP a_218000_429300# OUTP OUTP P w=20u l=10u
+  ad=0p pd=0u as=0p ps=0u
M1056 OUTP a_218000_429300# OUTP OUTP P w=20u l=10u
+  ad=0p pd=0u as=0p ps=0u
M1057 OUTP a_218000_429300# OUTP OUTP P w=20u l=10u
+  ad=0p pd=0u as=0p ps=0u
M1058 a_219600_914400# a_219600_914400# VSS VSS N w=10u l=1.6u
+  ad=45p pd=29u as=0p ps=0u
M1059 OUTP a_218000_429300# OUTP OUTP P w=20u l=10u
+  ad=0p pd=0u as=0p ps=0u
M1060 VDD a_218000_429300# VDD VDD P w=20u l=10u
+  ad=-0p pd=0u as=-0p ps=0u
M1061 a_329600_989500# a_216400_2012800# a_295600_991000# VSS N w=10u l=2.4u
+  ad=45p pd=29u as=0p ps=0u
M1062 a_255200_813800# PBOOST a_213500_813800# VDD P w=20u l=1.6u
+  ad=90p pd=49u as=0p ps=0u
M1063 OUTM a_218000_429300# OUTM OUTM P w=20u l=10u
+  ad=0p pd=0u as=0p ps=0u
M1064 a_219600_813800# a_217700_835900# a_213500_813800# VDD P w=20u l=1.6u
+  ad=90p pd=49u as=0p ps=0u
XR0A a_294000_353400# a_790714_1058800# RPP W=2.4e-06 L=0.000267857
XR0B a_790714_1058800# a_1326428_1058800# RPP W=2.4e-06 L=0.000267857
XR1A a_216400_1058800# a_220000_1058800# RPP W=2.4e-06 L=0.000267857
XR1B a_220000_1058800# a_755714_1058800# RPP W=2.4e-06 L=0.000267857
XR2A a_787114_1064800# a_790714_1064800# RPP W=2.4e-06 L=0.000267857
XR2B a_790714_1064800# a_1326428_1058800# RPP W=2.4e-06 L=0.000267857
XR3A a_216400_1064800# a_220000_1064800# RPP W=2.4e-06 L=0.000267857
XR3B a_220000_1064800# a_755714_1058800# RPP W=2.4e-06 L=0.000267857
XR4A a_787114_1064800# a_790714_1070800# RPP W=2.4e-06 L=0.000267857
XR4B a_790714_1070800# a_1326428_1070800# RPP W=2.4e-06 L=0.000267857
XR5A a_216400_1064800# a_220000_1070800# RPP W=2.4e-06 L=0.000267857
XR5B a_220000_1070800# a_755714_1070800# RPP W=2.4e-06 L=0.000267857
XR6A a_787114_1076800# a_790714_1076800# RPP W=2.4e-06 L=0.000267857
XR6B a_790714_1076800# a_1326428_1070800# RPP W=2.4e-06 L=0.000267857
XR7A a_216400_1076800# a_220000_1076800# RPP W=2.4e-06 L=0.000267857
XR7B a_220000_1076800# a_755714_1070800# RPP W=2.4e-06 L=0.000267857
XR8A a_787114_1076800# a_790714_1082800# RPP W=2.4e-06 L=0.000267857
XR8B a_790714_1082800# a_1326428_1082800# RPP W=2.4e-06 L=0.000267857
XR9A a_216400_1076800# a_220000_1082800# RPP W=2.4e-06 L=0.000267857
XR9B a_220000_1082800# a_755714_1082800# RPP W=2.4e-06 L=0.000267857
XR10A a_787114_1088800# a_790714_1088800# RPP W=2.4e-06 L=0.000267857
XR10B a_790714_1088800# a_1326428_1082800# RPP W=2.4e-06 L=0.000267857
XR11A a_216400_1088800# a_220000_1088800# RPP W=2.4e-06 L=0.000267857
XR11B a_220000_1088800# a_755714_1082800# RPP W=2.4e-06 L=0.000267857
XR12A a_787114_1088800# a_790714_1094800# RPP W=2.4e-06 L=0.000267857
XR12B a_790714_1094800# a_1326428_1094800# RPP W=2.4e-06 L=0.000267857
XR13A a_216400_1088800# a_220000_1094800# RPP W=2.4e-06 L=0.000267857
XR13B a_220000_1094800# a_755714_1094800# RPP W=2.4e-06 L=0.000267857
XR14A a_787114_1100800# a_790714_1100800# RPP W=2.4e-06 L=0.000267857
XR14B a_790714_1100800# a_1326428_1094800# RPP W=2.4e-06 L=0.000267857
XR15A a_216400_1100800# a_220000_1100800# RPP W=2.4e-06 L=0.000267857
XR15B a_220000_1100800# a_755714_1094800# RPP W=2.4e-06 L=0.000267857
XR16A a_787114_1100800# a_790714_1106800# RPP W=2.4e-06 L=0.000267857
XR16B a_790714_1106800# a_1326428_1106800# RPP W=2.4e-06 L=0.000267857
XR17A a_216400_1100800# a_220000_1106800# RPP W=2.4e-06 L=0.000267857
XR17B a_220000_1106800# a_755714_1106800# RPP W=2.4e-06 L=0.000267857
XR18A a_787114_1112800# a_790714_1112800# RPP W=2.4e-06 L=0.000267857
XR18B a_790714_1112800# a_1326428_1106800# RPP W=2.4e-06 L=0.000267857
XR19A a_216400_1112800# a_220000_1112800# RPP W=2.4e-06 L=0.000267857
XR19B a_220000_1112800# a_755714_1106800# RPP W=2.4e-06 L=0.000267857
XR20A a_787114_1112800# a_790714_1118800# RPP W=2.4e-06 L=0.000267857
XR20B a_790714_1118800# a_1326428_1118800# RPP W=2.4e-06 L=0.000267857
XR21A a_216400_1112800# a_220000_1118800# RPP W=2.4e-06 L=0.000267857
XR21B a_220000_1118800# a_755714_1118800# RPP W=2.4e-06 L=0.000267857
XR22A a_787114_1124800# a_790714_1124800# RPP W=2.4e-06 L=0.000267857
XR22B a_790714_1124800# a_1326428_1118800# RPP W=2.4e-06 L=0.000267857
XR23A a_216400_1124800# a_220000_1124800# RPP W=2.4e-06 L=0.000267857
XR23B a_220000_1124800# a_755714_1118800# RPP W=2.4e-06 L=0.000267857
XR24A a_787114_1124800# a_790714_1130800# RPP W=2.4e-06 L=0.000267857
XR24B a_790714_1130800# a_1326428_1130800# RPP W=2.4e-06 L=0.000267857
XR25A a_216400_1124800# a_220000_1130800# RPP W=2.4e-06 L=0.000267857
XR25B a_220000_1130800# a_755714_1130800# RPP W=2.4e-06 L=0.000267857
XR26A a_787114_1136800# a_790714_1136800# RPP W=2.4e-06 L=0.000267857
XR26B a_790714_1136800# a_1326428_1130800# RPP W=2.4e-06 L=0.000267857
XR27A a_216400_1136800# a_220000_1136800# RPP W=2.4e-06 L=0.000267857
XR27B a_220000_1136800# a_755714_1130800# RPP W=2.4e-06 L=0.000267857
XR28A a_787114_1136800# a_790714_1142800# RPP W=2.4e-06 L=0.000267857
XR28B a_790714_1142800# a_1326428_1142800# RPP W=2.4e-06 L=0.000267857
XR29A a_216400_1136800# a_220000_1142800# RPP W=2.4e-06 L=0.000267857
XR29B a_220000_1142800# a_755714_1142800# RPP W=2.4e-06 L=0.000267857
XR30A a_787114_1148800# a_790714_1148800# RPP W=2.4e-06 L=0.000267857
XR30B a_790714_1148800# a_1326428_1142800# RPP W=2.4e-06 L=0.000267857
XR31A a_216400_1148800# a_220000_1148800# RPP W=2.4e-06 L=0.000267857
XR31B a_220000_1148800# a_755714_1142800# RPP W=2.4e-06 L=0.000267857
XR32A a_787114_1148800# a_790714_1154800# RPP W=2.4e-06 L=0.000267857
XR32B a_790714_1154800# a_1326428_1154800# RPP W=2.4e-06 L=0.000267857
XR33A a_216400_1148800# a_220000_1154800# RPP W=2.4e-06 L=0.000267857
XR33B a_220000_1154800# a_755714_1154800# RPP W=2.4e-06 L=0.000267857
XR34A a_787114_1160800# a_790714_1160800# RPP W=2.4e-06 L=0.000267857
XR34B a_790714_1160800# a_1326428_1154800# RPP W=2.4e-06 L=0.000267857
XR35A a_216400_1160800# a_220000_1160800# RPP W=2.4e-06 L=0.000267857
XR35B a_220000_1160800# a_755714_1154800# RPP W=2.4e-06 L=0.000267857
XR36A a_787114_1160800# a_790714_1166800# RPP W=2.4e-06 L=0.000267857
XR36B a_790714_1166800# a_1326428_1166800# RPP W=2.4e-06 L=0.000267857
XR37A a_216400_1160800# a_220000_1166800# RPP W=2.4e-06 L=0.000267857
XR37B a_220000_1166800# a_755714_1166800# RPP W=2.4e-06 L=0.000267857
XR38A a_787114_1172800# a_790714_1172800# RPP W=2.4e-06 L=0.000267857
XR38B a_790714_1172800# a_1326428_1166800# RPP W=2.4e-06 L=0.000267857
XR39A a_216400_1172800# a_220000_1172800# RPP W=2.4e-06 L=0.000267857
XR39B a_220000_1172800# a_755714_1166800# RPP W=2.4e-06 L=0.000267857
XR40A a_787114_1172800# a_790714_1178800# RPP W=2.4e-06 L=0.000267857
XR40B a_790714_1178800# a_1326428_1178800# RPP W=2.4e-06 L=0.000267857
XR41A a_216400_1172800# a_220000_1178800# RPP W=2.4e-06 L=0.000267857
XR41B a_220000_1178800# a_755714_1178800# RPP W=2.4e-06 L=0.000267857
XR42A a_787114_1184800# a_790714_1184800# RPP W=2.4e-06 L=0.000267857
XR42B a_790714_1184800# a_1326428_1178800# RPP W=2.4e-06 L=0.000267857
XR43A a_216400_1184800# a_220000_1184800# RPP W=2.4e-06 L=0.000267857
XR43B a_220000_1184800# a_755714_1178800# RPP W=2.4e-06 L=0.000267857
XR44A a_787114_1184800# a_790714_1190800# RPP W=2.4e-06 L=0.000267857
XR44B a_790714_1190800# a_1326428_1190800# RPP W=2.4e-06 L=0.000267857
XR45A a_216400_1184800# a_220000_1190800# RPP W=2.4e-06 L=0.000267857
XR45B a_220000_1190800# a_755714_1190800# RPP W=2.4e-06 L=0.000267857
XR46A a_787114_1196800# a_790714_1196800# RPP W=2.4e-06 L=0.000267857
XR46B a_790714_1196800# a_1326428_1190800# RPP W=2.4e-06 L=0.000267857
XR47A a_216400_1196800# a_220000_1196800# RPP W=2.4e-06 L=0.000267857
XR47B a_220000_1196800# a_755714_1190800# RPP W=2.4e-06 L=0.000267857
XR48A a_787114_1196800# a_790714_1202800# RPP W=2.4e-06 L=0.000267857
XR48B a_790714_1202800# a_1326428_1202800# RPP W=2.4e-06 L=0.000267857
XR49A a_216400_1196800# a_220000_1202800# RPP W=2.4e-06 L=0.000267857
XR49B a_220000_1202800# a_755714_1202800# RPP W=2.4e-06 L=0.000267857
XR50A a_787114_1208800# a_790714_1208800# RPP W=2.4e-06 L=0.000267857
XR50B a_790714_1208800# a_1326428_1202800# RPP W=2.4e-06 L=0.000267857
XR51A a_216400_1208800# a_220000_1208800# RPP W=2.4e-06 L=0.000267857
XR51B a_220000_1208800# a_755714_1202800# RPP W=2.4e-06 L=0.000267857
XR52A a_787114_1208800# a_790714_1214800# RPP W=2.4e-06 L=0.000267857
XR52B a_790714_1214800# a_1326428_1214800# RPP W=2.4e-06 L=0.000267857
XR53A a_216400_1208800# a_220000_1214800# RPP W=2.4e-06 L=0.000267857
XR53B a_220000_1214800# a_755714_1214800# RPP W=2.4e-06 L=0.000267857
XR54A a_787114_1220800# a_790714_1220800# RPP W=2.4e-06 L=0.000267857
XR54B a_790714_1220800# a_1326428_1214800# RPP W=2.4e-06 L=0.000267857
XR55A a_216400_1220800# a_220000_1220800# RPP W=2.4e-06 L=0.000267857
XR55B a_220000_1220800# a_755714_1214800# RPP W=2.4e-06 L=0.000267857
XR56A a_787114_1220800# a_790714_1226800# RPP W=2.4e-06 L=0.000267857
XR56B a_790714_1226800# a_1326428_1226800# RPP W=2.4e-06 L=0.000267857
XR57A a_216400_1220800# a_220000_1226800# RPP W=2.4e-06 L=0.000267857
XR57B a_220000_1226800# a_755714_1226800# RPP W=2.4e-06 L=0.000267857
XR58A a_787114_1232800# a_790714_1232800# RPP W=2.4e-06 L=0.000267857
XR58B a_790714_1232800# a_1326428_1226800# RPP W=2.4e-06 L=0.000267857
XR59A a_216400_1232800# a_220000_1232800# RPP W=2.4e-06 L=0.000267857
XR59B a_220000_1232800# a_755714_1226800# RPP W=2.4e-06 L=0.000267857
XR60A a_787114_1232800# a_790714_1238800# RPP W=2.4e-06 L=0.000267857
XR60B a_790714_1238800# a_1326428_1238800# RPP W=2.4e-06 L=0.000267857
XR61A a_216400_1232800# a_220000_1238800# RPP W=2.4e-06 L=0.000267857
XR61B a_220000_1238800# a_755714_1238800# RPP W=2.4e-06 L=0.000267857
XR62A a_787114_1244800# a_790714_1244800# RPP W=2.4e-06 L=0.000267857
XR62B a_790714_1244800# a_1326428_1238800# RPP W=2.4e-06 L=0.000267857
XR63A a_216400_1244800# a_220000_1244800# RPP W=2.4e-06 L=0.000267857
XR63B a_220000_1244800# a_755714_1238800# RPP W=2.4e-06 L=0.000267857
XR64A a_787114_1244800# a_790714_1250800# RPP W=2.4e-06 L=0.000267857
XR64B a_790714_1250800# a_1326428_1250800# RPP W=2.4e-06 L=0.000267857
XR65A a_216400_1244800# a_220000_1250800# RPP W=2.4e-06 L=0.000267857
XR65B a_220000_1250800# a_755714_1250800# RPP W=2.4e-06 L=0.000267857
XR66A a_787114_1256800# a_790714_1256800# RPP W=2.4e-06 L=0.000267857
XR66B a_790714_1256800# a_1326428_1250800# RPP W=2.4e-06 L=0.000267857
XR67A a_216400_1256800# a_220000_1256800# RPP W=2.4e-06 L=0.000267857
XR67B a_220000_1256800# a_755714_1250800# RPP W=2.4e-06 L=0.000267857
XR68A a_787114_1256800# a_790714_1262800# RPP W=2.4e-06 L=0.000267857
XR68B a_790714_1262800# a_1326428_1262800# RPP W=2.4e-06 L=0.000267857
XR69A a_216400_1256800# a_220000_1262800# RPP W=2.4e-06 L=0.000267857
XR69B a_220000_1262800# a_755714_1262800# RPP W=2.4e-06 L=0.000267857
XR70A a_787114_1268800# a_790714_1268800# RPP W=2.4e-06 L=0.000267857
XR70B a_790714_1268800# a_1326428_1262800# RPP W=2.4e-06 L=0.000267857
XR71A a_216400_1268800# a_220000_1268800# RPP W=2.4e-06 L=0.000267857
XR71B a_220000_1268800# a_755714_1262800# RPP W=2.4e-06 L=0.000267857
XR72A a_787114_1268800# a_790714_1274800# RPP W=2.4e-06 L=0.000267857
XR72B a_790714_1274800# a_1326428_1274800# RPP W=2.4e-06 L=0.000267857
XR73A a_216400_1268800# a_220000_1274800# RPP W=2.4e-06 L=0.000267857
XR73B a_220000_1274800# a_755714_1274800# RPP W=2.4e-06 L=0.000267857
XR74A a_787114_1280800# a_790714_1280800# RPP W=2.4e-06 L=0.000267857
XR74B a_790714_1280800# a_1326428_1274800# RPP W=2.4e-06 L=0.000267857
XR75A a_216400_1280800# a_220000_1280800# RPP W=2.4e-06 L=0.000267857
XR75B a_220000_1280800# a_755714_1274800# RPP W=2.4e-06 L=0.000267857
XR76A a_787114_1280800# a_790714_1286800# RPP W=2.4e-06 L=0.000267857
XR76B a_790714_1286800# a_1326428_1286800# RPP W=2.4e-06 L=0.000267857
XR77A a_216400_1280800# a_220000_1286800# RPP W=2.4e-06 L=0.000267857
XR77B a_220000_1286800# a_755714_1286800# RPP W=2.4e-06 L=0.000267857
XR78A a_787114_1292800# a_790714_1292800# RPP W=2.4e-06 L=0.000267857
XR78B a_790714_1292800# a_1326428_1286800# RPP W=2.4e-06 L=0.000267857
XR79A a_216400_1292800# a_220000_1292800# RPP W=2.4e-06 L=0.000267857
XR79B a_220000_1292800# a_755714_1286800# RPP W=2.4e-06 L=0.000267857
XR80A a_787114_1292800# a_790714_1298800# RPP W=2.4e-06 L=0.000267857
XR80B a_790714_1298800# a_1326428_1298800# RPP W=2.4e-06 L=0.000267857
XR81A a_216400_1292800# a_220000_1298800# RPP W=2.4e-06 L=0.000267857
XR81B a_220000_1298800# a_755714_1298800# RPP W=2.4e-06 L=0.000267857
XR82A a_787114_1304800# a_790714_1304800# RPP W=2.4e-06 L=0.000267857
XR82B a_790714_1304800# a_1326428_1298800# RPP W=2.4e-06 L=0.000267857
XR83A a_216400_1304800# a_220000_1304800# RPP W=2.4e-06 L=0.000267857
XR83B a_220000_1304800# a_755714_1298800# RPP W=2.4e-06 L=0.000267857
XR84A a_787114_1304800# a_790714_1310800# RPP W=2.4e-06 L=0.000267857
XR84B a_790714_1310800# a_1326428_1310800# RPP W=2.4e-06 L=0.000267857
XR85A a_216400_1304800# a_220000_1310800# RPP W=2.4e-06 L=0.000267857
XR85B a_220000_1310800# a_755714_1310800# RPP W=2.4e-06 L=0.000267857
XR86A a_787114_1316800# a_790714_1316800# RPP W=2.4e-06 L=0.000267857
XR86B a_790714_1316800# a_1326428_1310800# RPP W=2.4e-06 L=0.000267857
XR87A a_216400_1316800# a_220000_1316800# RPP W=2.4e-06 L=0.000267857
XR87B a_220000_1316800# a_755714_1310800# RPP W=2.4e-06 L=0.000267857
XR88A a_787114_1316800# a_790714_1322800# RPP W=2.4e-06 L=0.000267857
XR88B a_790714_1322800# a_1326428_1322800# RPP W=2.4e-06 L=0.000267857
XR89A a_216400_1316800# a_220000_1322800# RPP W=2.4e-06 L=0.000267857
XR89B a_220000_1322800# a_755714_1322800# RPP W=2.4e-06 L=0.000267857
XR90A a_787114_1328800# a_790714_1328800# RPP W=2.4e-06 L=0.000267857
XR90B a_790714_1328800# a_1326428_1322800# RPP W=2.4e-06 L=0.000267857
XR91A a_216400_1328800# a_220000_1328800# RPP W=2.4e-06 L=0.000267857
XR91B a_220000_1328800# a_755714_1322800# RPP W=2.4e-06 L=0.000267857
XR92A a_787114_1328800# a_790714_1334800# RPP W=2.4e-06 L=0.000267857
XR92B a_790714_1334800# a_1326428_1334800# RPP W=2.4e-06 L=0.000267857
XR93A a_216400_1328800# a_220000_1334800# RPP W=2.4e-06 L=0.000267857
XR93B a_220000_1334800# a_755714_1334800# RPP W=2.4e-06 L=0.000267857
XR94A a_787114_1340800# a_790714_1340800# RPP W=2.4e-06 L=0.000267857
XR94B a_790714_1340800# a_1326428_1334800# RPP W=2.4e-06 L=0.000267857
XR95A a_216400_1340800# a_220000_1340800# RPP W=2.4e-06 L=0.000267857
XR95B a_220000_1340800# a_755714_1334800# RPP W=2.4e-06 L=0.000267857
XR96A a_787114_1340800# a_790714_1346800# RPP W=2.4e-06 L=0.000267857
XR96B a_790714_1346800# a_1326428_1346800# RPP W=2.4e-06 L=0.000267857
XR97A a_216400_1340800# a_220000_1346800# RPP W=2.4e-06 L=0.000267857
XR97B a_220000_1346800# a_755714_1346800# RPP W=2.4e-06 L=0.000267857
XR98A a_787114_1352800# a_790714_1352800# RPP W=2.4e-06 L=0.000267857
XR98B a_790714_1352800# a_1326428_1346800# RPP W=2.4e-06 L=0.000267857
XR99A a_216400_1352800# a_220000_1352800# RPP W=2.4e-06 L=0.000267857
XR99B a_220000_1352800# a_755714_1346800# RPP W=2.4e-06 L=0.000267857
XR100A a_787114_1352800# a_790714_1358800# RPP W=2.4e-06 L=0.000267857
XR100B a_790714_1358800# a_1326428_1358800# RPP W=2.4e-06 L=0.000267857
XR101A a_216400_1352800# a_220000_1358800# RPP W=2.4e-06 L=0.000267857
XR101B a_220000_1358800# a_755714_1358800# RPP W=2.4e-06 L=0.000267857
XR102A a_787114_1364800# a_790714_1364800# RPP W=2.4e-06 L=0.000267857
XR102B a_790714_1364800# a_1326428_1358800# RPP W=2.4e-06 L=0.000267857
XR103A a_216400_1364800# a_220000_1364800# RPP W=2.4e-06 L=0.000267857
XR103B a_220000_1364800# a_755714_1358800# RPP W=2.4e-06 L=0.000267857
XR104A a_787114_1364800# a_790714_1370800# RPP W=2.4e-06 L=0.000267857
XR104B a_790714_1370800# a_1326428_1370800# RPP W=2.4e-06 L=0.000267857
XR105A a_216400_1364800# a_220000_1370800# RPP W=2.4e-06 L=0.000267857
XR105B a_220000_1370800# a_755714_1370800# RPP W=2.4e-06 L=0.000267857
XR106A a_787114_1376800# a_790714_1376800# RPP W=2.4e-06 L=0.000267857
XR106B a_790714_1376800# a_1326428_1370800# RPP W=2.4e-06 L=0.000267857
XR107A a_216400_1376800# a_220000_1376800# RPP W=2.4e-06 L=0.000267857
XR107B a_220000_1376800# a_755714_1370800# RPP W=2.4e-06 L=0.000267857
XR108A a_787114_1376800# a_790714_1382800# RPP W=2.4e-06 L=0.000267857
XR108B a_790714_1382800# a_1326428_1382800# RPP W=2.4e-06 L=0.000267857
XR109A a_216400_1376800# a_220000_1382800# RPP W=2.4e-06 L=0.000267857
XR109B a_220000_1382800# a_755714_1382800# RPP W=2.4e-06 L=0.000267857
XR110A a_787114_1388800# a_790714_1388800# RPP W=2.4e-06 L=0.000267857
XR110B a_790714_1388800# a_1326428_1382800# RPP W=2.4e-06 L=0.000267857
XR111A a_216400_1388800# a_220000_1388800# RPP W=2.4e-06 L=0.000267857
XR111B a_220000_1388800# a_755714_1382800# RPP W=2.4e-06 L=0.000267857
XR112A a_787114_1388800# a_790714_1394800# RPP W=2.4e-06 L=0.000267857
XR112B a_790714_1394800# a_1326428_1394800# RPP W=2.4e-06 L=0.000267857
XR113A a_216400_1388800# a_220000_1394800# RPP W=2.4e-06 L=0.000267857
XR113B a_220000_1394800# a_755714_1394800# RPP W=2.4e-06 L=0.000267857
XR114A a_787114_1400800# a_790714_1400800# RPP W=2.4e-06 L=0.000267857
XR114B a_790714_1400800# a_1326428_1394800# RPP W=2.4e-06 L=0.000267857
XR115A a_216400_1400800# a_220000_1400800# RPP W=2.4e-06 L=0.000267857
XR115B a_220000_1400800# a_755714_1394800# RPP W=2.4e-06 L=0.000267857
XR116A a_787114_1400800# a_790714_1406800# RPP W=2.4e-06 L=0.000267857
XR116B a_790714_1406800# a_1326428_1406800# RPP W=2.4e-06 L=0.000267857
XR117A a_216400_1400800# a_220000_1406800# RPP W=2.4e-06 L=0.000267857
XR117B a_220000_1406800# a_755714_1406800# RPP W=2.4e-06 L=0.000267857
XR118A a_787114_1412800# a_790714_1412800# RPP W=2.4e-06 L=0.000267857
XR118B a_790714_1412800# a_1326428_1406800# RPP W=2.4e-06 L=0.000267857
XR119A a_216400_1412800# a_220000_1412800# RPP W=2.4e-06 L=0.000267857
XR119B a_220000_1412800# a_755714_1406800# RPP W=2.4e-06 L=0.000267857
XR120A a_787114_1412800# a_790714_1418800# RPP W=2.4e-06 L=0.000267857
XR120B a_790714_1418800# a_1326428_1418800# RPP W=2.4e-06 L=0.000267857
XR121A a_216400_1412800# a_220000_1418800# RPP W=2.4e-06 L=0.000267857
XR121B a_220000_1418800# a_755714_1418800# RPP W=2.4e-06 L=0.000267857
XR122A a_787114_1424800# a_790714_1424800# RPP W=2.4e-06 L=0.000267857
XR122B a_790714_1424800# a_1326428_1418800# RPP W=2.4e-06 L=0.000267857
XR123A a_216400_1424800# a_220000_1424800# RPP W=2.4e-06 L=0.000267857
XR123B a_220000_1424800# a_755714_1418800# RPP W=2.4e-06 L=0.000267857
XR124A a_787114_1424800# a_790714_1430800# RPP W=2.4e-06 L=0.000267857
XR124B a_790714_1430800# a_1326428_1430800# RPP W=2.4e-06 L=0.000267857
XR125A a_216400_1424800# a_220000_1430800# RPP W=2.4e-06 L=0.000267857
XR125B a_220000_1430800# a_755714_1430800# RPP W=2.4e-06 L=0.000267857
XR126A a_787114_1436800# a_790714_1436800# RPP W=2.4e-06 L=0.000267857
XR126B a_790714_1436800# a_1326428_1430800# RPP W=2.4e-06 L=0.000267857
XR127A a_216400_1436800# a_220000_1436800# RPP W=2.4e-06 L=0.000267857
XR127B a_220000_1436800# a_755714_1430800# RPP W=2.4e-06 L=0.000267857
XR128A a_787114_1436800# a_790714_1442800# RPP W=2.4e-06 L=0.000267857
XR128B a_790714_1442800# a_1326428_1442800# RPP W=2.4e-06 L=0.000267857
XR129A a_216400_1436800# a_220000_1442800# RPP W=2.4e-06 L=0.000267857
XR129B a_220000_1442800# a_755714_1442800# RPP W=2.4e-06 L=0.000267857
XR130A a_787114_1448800# a_790714_1448800# RPP W=2.4e-06 L=0.000267857
XR130B a_790714_1448800# a_1326428_1442800# RPP W=2.4e-06 L=0.000267857
XR131A a_216400_1448800# a_220000_1448800# RPP W=2.4e-06 L=0.000267857
XR131B a_220000_1448800# a_755714_1442800# RPP W=2.4e-06 L=0.000267857
XR132A a_787114_1448800# a_790714_1454800# RPP W=2.4e-06 L=0.000267857
XR132B a_790714_1454800# a_1326428_1454800# RPP W=2.4e-06 L=0.000267857
XR133A a_216400_1448800# a_220000_1454800# RPP W=2.4e-06 L=0.000267857
XR133B a_220000_1454800# a_755714_1454800# RPP W=2.4e-06 L=0.000267857
XR134A a_787114_1460800# a_790714_1460800# RPP W=2.4e-06 L=0.000267857
XR134B a_790714_1460800# a_1326428_1454800# RPP W=2.4e-06 L=0.000267857
XR135A a_216400_1460800# a_220000_1460800# RPP W=2.4e-06 L=0.000267857
XR135B a_220000_1460800# a_755714_1454800# RPP W=2.4e-06 L=0.000267857
XR136A a_787114_1460800# a_790714_1466800# RPP W=2.4e-06 L=0.000267857
XR136B a_790714_1466800# a_1326428_1466800# RPP W=2.4e-06 L=0.000267857
XR137A a_216400_1460800# a_220000_1466800# RPP W=2.4e-06 L=0.000267857
XR137B a_220000_1466800# a_755714_1466800# RPP W=2.4e-06 L=0.000267857
XR138A a_787114_1472800# a_790714_1472800# RPP W=2.4e-06 L=0.000267857
XR138B a_790714_1472800# a_1326428_1466800# RPP W=2.4e-06 L=0.000267857
XR139A a_216400_1472800# a_220000_1472800# RPP W=2.4e-06 L=0.000267857
XR139B a_220000_1472800# a_755714_1466800# RPP W=2.4e-06 L=0.000267857
XR140A a_787114_1472800# a_790714_1478800# RPP W=2.4e-06 L=0.000267857
XR140B a_790714_1478800# a_1326428_1478800# RPP W=2.4e-06 L=0.000267857
XR141A a_216400_1472800# a_220000_1478800# RPP W=2.4e-06 L=0.000267857
XR141B a_220000_1478800# a_755714_1478800# RPP W=2.4e-06 L=0.000267857
XR142A a_787114_1484800# a_790714_1484800# RPP W=2.4e-06 L=0.000267857
XR142B a_790714_1484800# a_1326428_1478800# RPP W=2.4e-06 L=0.000267857
XR143A a_216400_1484800# a_220000_1484800# RPP W=2.4e-06 L=0.000267857
XR143B a_220000_1484800# a_755714_1478800# RPP W=2.4e-06 L=0.000267857
XR144A a_787114_1484800# a_790714_1490800# RPP W=2.4e-06 L=0.000267857
XR144B a_790714_1490800# a_1326428_1490800# RPP W=2.4e-06 L=0.000267857
XR145A a_216400_1484800# a_220000_1490800# RPP W=2.4e-06 L=0.000267857
XR145B a_220000_1490800# a_755714_1490800# RPP W=2.4e-06 L=0.000267857
XR146A a_787114_1496800# a_790714_1496800# RPP W=2.4e-06 L=0.000267857
XR146B a_790714_1496800# a_1326428_1490800# RPP W=2.4e-06 L=0.000267857
XR147A a_216400_1496800# a_220000_1496800# RPP W=2.4e-06 L=0.000267857
XR147B a_220000_1496800# a_755714_1490800# RPP W=2.4e-06 L=0.000267857
XR148A a_787114_1496800# a_790714_1502800# RPP W=2.4e-06 L=0.000267857
XR148B a_790714_1502800# a_1326428_1502800# RPP W=2.4e-06 L=0.000267857
XR149A a_216400_1496800# a_220000_1502800# RPP W=2.4e-06 L=0.000267857
XR149B a_220000_1502800# a_755714_1502800# RPP W=2.4e-06 L=0.000267857
XR150A a_787114_1508800# a_790714_1508800# RPP W=2.4e-06 L=0.000267857
XR150B a_790714_1508800# a_1326428_1502800# RPP W=2.4e-06 L=0.000267857
XR151A a_216400_1508800# a_220000_1508800# RPP W=2.4e-06 L=0.000267857
XR151B a_220000_1508800# a_755714_1502800# RPP W=2.4e-06 L=0.000267857
XR152A a_787114_1508800# a_790714_1514800# RPP W=2.4e-06 L=0.000267857
XR152B a_790714_1514800# a_1326428_1514800# RPP W=2.4e-06 L=0.000267857
XR153A a_216400_1508800# a_220000_1514800# RPP W=2.4e-06 L=0.000267857
XR153B a_220000_1514800# a_755714_1514800# RPP W=2.4e-06 L=0.000267857
XR154A a_787114_1520800# a_790714_1520800# RPP W=2.4e-06 L=0.000267857
XR154B a_790714_1520800# a_1326428_1514800# RPP W=2.4e-06 L=0.000267857
XR155A a_216400_1520800# a_220000_1520800# RPP W=2.4e-06 L=0.000267857
XR155B a_220000_1520800# a_755714_1514800# RPP W=2.4e-06 L=0.000267857
XR156A a_787114_1520800# a_790714_1526800# RPP W=2.4e-06 L=0.000267857
XR156B a_790714_1526800# a_1326428_1526800# RPP W=2.4e-06 L=0.000267857
XR157A a_216400_1520800# a_220000_1526800# RPP W=2.4e-06 L=0.000267857
XR157B a_220000_1526800# a_755714_1526800# RPP W=2.4e-06 L=0.000267857
XR158A a_787114_1532800# a_790714_1532800# RPP W=2.4e-06 L=0.000267857
XR158B a_790714_1532800# a_1326428_1526800# RPP W=2.4e-06 L=0.000267857
XR159A a_216400_1532800# a_220000_1532800# RPP W=2.4e-06 L=0.000267857
XR159B a_220000_1532800# a_755714_1526800# RPP W=2.4e-06 L=0.000267857
XR160A a_787114_1532800# a_790714_1538800# RPP W=2.4e-06 L=0.000267857
XR160B a_790714_1538800# a_1326428_1538800# RPP W=2.4e-06 L=0.000267857
XR161A a_216400_1532800# a_220000_1538800# RPP W=2.4e-06 L=0.000267857
XR161B a_220000_1538800# a_755714_1538800# RPP W=2.4e-06 L=0.000267857
XR162A a_787114_1544800# a_790714_1544800# RPP W=2.4e-06 L=0.000267857
XR162B a_790714_1544800# a_1326428_1538800# RPP W=2.4e-06 L=0.000267857
XR163A a_216400_1544800# a_220000_1544800# RPP W=2.4e-06 L=0.000267857
XR163B a_220000_1544800# a_755714_1538800# RPP W=2.4e-06 L=0.000267857
XR164A a_787114_1544800# a_790714_1550800# RPP W=2.4e-06 L=0.000267857
XR164B a_790714_1550800# a_1326428_1550800# RPP W=2.4e-06 L=0.000267857
XR165A a_216400_1544800# a_220000_1550800# RPP W=2.4e-06 L=0.000267857
XR165B a_220000_1550800# a_755714_1550800# RPP W=2.4e-06 L=0.000267857
XR166A a_787114_1556800# a_790714_1556800# RPP W=2.4e-06 L=0.000267857
XR166B a_790714_1556800# a_1326428_1550800# RPP W=2.4e-06 L=0.000267857
XR167A a_216400_1556800# a_220000_1556800# RPP W=2.4e-06 L=0.000267857
XR167B a_220000_1556800# a_755714_1550800# RPP W=2.4e-06 L=0.000267857
XR168A a_787114_1556800# a_790714_1562800# RPP W=2.4e-06 L=0.000267857
XR168B a_790714_1562800# a_1326428_1562800# RPP W=2.4e-06 L=0.000267857
XR169A a_216400_1556800# a_220000_1562800# RPP W=2.4e-06 L=0.000267857
XR169B a_220000_1562800# a_755714_1562800# RPP W=2.4e-06 L=0.000267857
XR170A a_787114_1568800# a_790714_1568800# RPP W=2.4e-06 L=0.000267857
XR170B a_790714_1568800# a_1326428_1562800# RPP W=2.4e-06 L=0.000267857
XR171A a_216400_1568800# a_220000_1568800# RPP W=2.4e-06 L=0.000267857
XR171B a_220000_1568800# a_755714_1562800# RPP W=2.4e-06 L=0.000267857
XR172A a_787114_1568800# a_790714_1574800# RPP W=2.4e-06 L=0.000267857
XR172B a_790714_1574800# a_1326428_1574800# RPP W=2.4e-06 L=0.000267857
XR173A a_216400_1568800# a_220000_1574800# RPP W=2.4e-06 L=0.000267857
XR173B a_220000_1574800# a_755714_1574800# RPP W=2.4e-06 L=0.000267857
XR174A a_787114_1580800# a_790714_1580800# RPP W=2.4e-06 L=0.000267857
XR174B a_790714_1580800# a_1326428_1574800# RPP W=2.4e-06 L=0.000267857
XR175A a_216400_1580800# a_220000_1580800# RPP W=2.4e-06 L=0.000267857
XR175B a_220000_1580800# a_755714_1574800# RPP W=2.4e-06 L=0.000267857
XR176A a_787114_1580800# a_790714_1586800# RPP W=2.4e-06 L=0.000267857
XR176B a_790714_1586800# a_1326428_1586800# RPP W=2.4e-06 L=0.000267857
XR177A a_216400_1580800# a_220000_1586800# RPP W=2.4e-06 L=0.000267857
XR177B a_220000_1586800# a_755714_1586800# RPP W=2.4e-06 L=0.000267857
XR178A a_787114_1592800# a_790714_1592800# RPP W=2.4e-06 L=0.000267857
XR178B a_790714_1592800# a_1326428_1586800# RPP W=2.4e-06 L=0.000267857
XR179A a_216400_1592800# a_220000_1592800# RPP W=2.4e-06 L=0.000267857
XR179B a_220000_1592800# a_755714_1586800# RPP W=2.4e-06 L=0.000267857
XR180A a_787114_1592800# a_790714_1598800# RPP W=2.4e-06 L=0.000267857
XR180B a_790714_1598800# a_1326428_1598800# RPP W=2.4e-06 L=0.000267857
XR181A a_216400_1592800# a_220000_1598800# RPP W=2.4e-06 L=0.000267857
XR181B a_220000_1598800# a_755714_1598800# RPP W=2.4e-06 L=0.000267857
XR182A a_787114_1604800# a_790714_1604800# RPP W=2.4e-06 L=0.000267857
XR182B a_790714_1604800# a_1326428_1598800# RPP W=2.4e-06 L=0.000267857
XR183A a_216400_1604800# a_220000_1604800# RPP W=2.4e-06 L=0.000267857
XR183B a_220000_1604800# a_755714_1598800# RPP W=2.4e-06 L=0.000267857
XR184A a_787114_1604800# a_790714_1610800# RPP W=2.4e-06 L=0.000267857
XR184B a_790714_1610800# a_1326428_1610800# RPP W=2.4e-06 L=0.000267857
XR185A a_216400_1604800# a_220000_1610800# RPP W=2.4e-06 L=0.000267857
XR185B a_220000_1610800# a_755714_1610800# RPP W=2.4e-06 L=0.000267857
XR186A a_787114_1616800# a_790714_1616800# RPP W=2.4e-06 L=0.000267857
XR186B a_790714_1616800# a_1326428_1610800# RPP W=2.4e-06 L=0.000267857
XR187A a_216400_1616800# a_220000_1616800# RPP W=2.4e-06 L=0.000267857
XR187B a_220000_1616800# a_755714_1610800# RPP W=2.4e-06 L=0.000267857
XR188A a_787114_1616800# a_790714_1622800# RPP W=2.4e-06 L=0.000267857
XR188B a_790714_1622800# a_1326428_1622800# RPP W=2.4e-06 L=0.000267857
XR189A a_216400_1616800# a_220000_1622800# RPP W=2.4e-06 L=0.000267857
XR189B a_220000_1622800# a_755714_1622800# RPP W=2.4e-06 L=0.000267857
XR190A a_787114_1628800# a_790714_1628800# RPP W=2.4e-06 L=0.000267857
XR190B a_790714_1628800# a_1326428_1622800# RPP W=2.4e-06 L=0.000267857
XR191A a_216400_1628800# a_220000_1628800# RPP W=2.4e-06 L=0.000267857
XR191B a_220000_1628800# a_755714_1622800# RPP W=2.4e-06 L=0.000267857
XR192A a_787114_1628800# a_790714_1634800# RPP W=2.4e-06 L=0.000267857
XR192B a_790714_1634800# a_1326428_1634800# RPP W=2.4e-06 L=0.000267857
XR193A a_216400_1628800# a_220000_1634800# RPP W=2.4e-06 L=0.000267857
XR193B a_220000_1634800# a_755714_1634800# RPP W=2.4e-06 L=0.000267857
XR194A a_787114_1640800# a_790714_1640800# RPP W=2.4e-06 L=0.000267857
XR194B a_790714_1640800# a_1326428_1634800# RPP W=2.4e-06 L=0.000267857
XR195A a_216400_1640800# a_220000_1640800# RPP W=2.4e-06 L=0.000267857
XR195B a_220000_1640800# a_755714_1634800# RPP W=2.4e-06 L=0.000267857
XR196A a_787114_1640800# a_790714_1646800# RPP W=2.4e-06 L=0.000267857
XR196B a_790714_1646800# a_1326428_1646800# RPP W=2.4e-06 L=0.000267857
XR197A a_216400_1640800# a_220000_1646800# RPP W=2.4e-06 L=0.000267857
XR197B a_220000_1646800# a_755714_1646800# RPP W=2.4e-06 L=0.000267857
XR198A a_787114_1652800# a_790714_1652800# RPP W=2.4e-06 L=0.000267857
XR198B a_790714_1652800# a_1326428_1646800# RPP W=2.4e-06 L=0.000267857
XR199A a_216400_1652800# a_220000_1652800# RPP W=2.4e-06 L=0.000267857
XR199B a_220000_1652800# a_755714_1646800# RPP W=2.4e-06 L=0.000267857
XR200A a_787114_1652800# a_790714_1658800# RPP W=2.4e-06 L=0.000267857
XR200B a_790714_1658800# a_1326428_1658800# RPP W=2.4e-06 L=0.000267857
XR201A a_216400_1652800# a_220000_1658800# RPP W=2.4e-06 L=0.000267857
XR201B a_220000_1658800# a_755714_1658800# RPP W=2.4e-06 L=0.000267857
XR202A a_787114_1664800# a_790714_1664800# RPP W=2.4e-06 L=0.000267857
XR202B a_790714_1664800# a_1326428_1658800# RPP W=2.4e-06 L=0.000267857
XR203A a_216400_1664800# a_220000_1664800# RPP W=2.4e-06 L=0.000267857
XR203B a_220000_1664800# a_755714_1658800# RPP W=2.4e-06 L=0.000267857
XR204A a_787114_1664800# a_790714_1670800# RPP W=2.4e-06 L=0.000267857
XR204B a_790714_1670800# a_1326428_1670800# RPP W=2.4e-06 L=0.000267857
XR205A a_216400_1664800# a_220000_1670800# RPP W=2.4e-06 L=0.000267857
XR205B a_220000_1670800# a_755714_1670800# RPP W=2.4e-06 L=0.000267857
XR206A a_787114_1676800# a_790714_1676800# RPP W=2.4e-06 L=0.000267857
XR206B a_790714_1676800# a_1326428_1670800# RPP W=2.4e-06 L=0.000267857
XR207A a_216400_1676800# a_220000_1676800# RPP W=2.4e-06 L=0.000267857
XR207B a_220000_1676800# a_755714_1670800# RPP W=2.4e-06 L=0.000267857
XR208A a_787114_1676800# a_790714_1682800# RPP W=2.4e-06 L=0.000267857
XR208B a_790714_1682800# a_1326428_1682800# RPP W=2.4e-06 L=0.000267857
XR209A a_216400_1676800# a_220000_1682800# RPP W=2.4e-06 L=0.000267857
XR209B a_220000_1682800# a_755714_1682800# RPP W=2.4e-06 L=0.000267857
XR210A a_787114_1688800# a_790714_1688800# RPP W=2.4e-06 L=0.000267857
XR210B a_790714_1688800# a_1326428_1682800# RPP W=2.4e-06 L=0.000267857
XR211A a_216400_1688800# a_220000_1688800# RPP W=2.4e-06 L=0.000267857
XR211B a_220000_1688800# a_755714_1682800# RPP W=2.4e-06 L=0.000267857
XR212A a_787114_1688800# a_790714_1694800# RPP W=2.4e-06 L=0.000267857
XR212B a_790714_1694800# a_1326428_1694800# RPP W=2.4e-06 L=0.000267857
XR213A a_216400_1688800# a_220000_1694800# RPP W=2.4e-06 L=0.000267857
XR213B a_220000_1694800# a_755714_1694800# RPP W=2.4e-06 L=0.000267857
XR214A a_787114_1700800# a_790714_1700800# RPP W=2.4e-06 L=0.000267857
XR214B a_790714_1700800# a_1326428_1694800# RPP W=2.4e-06 L=0.000267857
XR215A a_216400_1700800# a_220000_1700800# RPP W=2.4e-06 L=0.000267857
XR215B a_220000_1700800# a_755714_1694800# RPP W=2.4e-06 L=0.000267857
XR216A a_787114_1700800# a_790714_1706800# RPP W=2.4e-06 L=0.000267857
XR216B a_790714_1706800# a_1326428_1706800# RPP W=2.4e-06 L=0.000267857
XR217A a_216400_1700800# a_220000_1706800# RPP W=2.4e-06 L=0.000267857
XR217B a_220000_1706800# a_755714_1706800# RPP W=2.4e-06 L=0.000267857
XR218A a_787114_1712800# a_790714_1712800# RPP W=2.4e-06 L=0.000267857
XR218B a_790714_1712800# a_1326428_1706800# RPP W=2.4e-06 L=0.000267857
XR219A a_216400_1712800# a_220000_1712800# RPP W=2.4e-06 L=0.000267857
XR219B a_220000_1712800# a_755714_1706800# RPP W=2.4e-06 L=0.000267857
XR220A a_787114_1712800# a_790714_1718800# RPP W=2.4e-06 L=0.000267857
XR220B a_790714_1718800# a_1326428_1718800# RPP W=2.4e-06 L=0.000267857
XR221A a_216400_1712800# a_220000_1718800# RPP W=2.4e-06 L=0.000267857
XR221B a_220000_1718800# a_755714_1718800# RPP W=2.4e-06 L=0.000267857
XR222A a_787114_1724800# a_790714_1724800# RPP W=2.4e-06 L=0.000267857
XR222B a_790714_1724800# a_1326428_1718800# RPP W=2.4e-06 L=0.000267857
XR223A a_216400_1724800# a_220000_1724800# RPP W=2.4e-06 L=0.000267857
XR223B a_220000_1724800# a_755714_1718800# RPP W=2.4e-06 L=0.000267857
XR224A a_787114_1724800# a_790714_1730800# RPP W=2.4e-06 L=0.000267857
XR224B a_790714_1730800# a_1326428_1730800# RPP W=2.4e-06 L=0.000267857
XR225A a_216400_1724800# a_220000_1730800# RPP W=2.4e-06 L=0.000267857
XR225B a_220000_1730800# a_755714_1730800# RPP W=2.4e-06 L=0.000267857
XR226A a_787114_1736800# a_790714_1736800# RPP W=2.4e-06 L=0.000267857
XR226B a_790714_1736800# a_1326428_1730800# RPP W=2.4e-06 L=0.000267857
XR227A a_216400_1736800# a_220000_1736800# RPP W=2.4e-06 L=0.000267857
XR227B a_220000_1736800# a_755714_1730800# RPP W=2.4e-06 L=0.000267857
XR228A a_787114_1736800# a_790714_1742800# RPP W=2.4e-06 L=0.000267857
XR228B a_790714_1742800# a_1326428_1742800# RPP W=2.4e-06 L=0.000267857
XR229A a_216400_1736800# a_220000_1742800# RPP W=2.4e-06 L=0.000267857
XR229B a_220000_1742800# a_755714_1742800# RPP W=2.4e-06 L=0.000267857
XR230A a_787114_1748800# a_790714_1748800# RPP W=2.4e-06 L=0.000267857
XR230B a_790714_1748800# a_1326428_1742800# RPP W=2.4e-06 L=0.000267857
XR231A a_216400_1748800# a_220000_1748800# RPP W=2.4e-06 L=0.000267857
XR231B a_220000_1748800# a_755714_1742800# RPP W=2.4e-06 L=0.000267857
XR232A a_787114_1748800# a_790714_1754800# RPP W=2.4e-06 L=0.000267857
XR232B a_790714_1754800# a_1326428_1754800# RPP W=2.4e-06 L=0.000267857
XR233A a_216400_1748800# a_220000_1754800# RPP W=2.4e-06 L=0.000267857
XR233B a_220000_1754800# a_755714_1754800# RPP W=2.4e-06 L=0.000267857
XR234A a_787114_1760800# a_790714_1760800# RPP W=2.4e-06 L=0.000267857
XR234B a_790714_1760800# a_1326428_1754800# RPP W=2.4e-06 L=0.000267857
XR235A a_216400_1760800# a_220000_1760800# RPP W=2.4e-06 L=0.000267857
XR235B a_220000_1760800# a_755714_1754800# RPP W=2.4e-06 L=0.000267857
XR236A a_787114_1760800# a_790714_1766800# RPP W=2.4e-06 L=0.000267857
XR236B a_790714_1766800# a_1326428_1766800# RPP W=2.4e-06 L=0.000267857
XR237A a_216400_1760800# a_220000_1766800# RPP W=2.4e-06 L=0.000267857
XR237B a_220000_1766800# a_755714_1766800# RPP W=2.4e-06 L=0.000267857
XR238A a_787114_1772800# a_790714_1772800# RPP W=2.4e-06 L=0.000267857
XR238B a_790714_1772800# a_1326428_1766800# RPP W=2.4e-06 L=0.000267857
XR239A a_216400_1772800# a_220000_1772800# RPP W=2.4e-06 L=0.000267857
XR239B a_220000_1772800# a_755714_1766800# RPP W=2.4e-06 L=0.000267857
XR240A a_787114_1772800# a_790714_1778800# RPP W=2.4e-06 L=0.000267857
XR240B a_790714_1778800# a_1326428_1778800# RPP W=2.4e-06 L=0.000267857
XR241A a_216400_1772800# a_220000_1778800# RPP W=2.4e-06 L=0.000267857
XR241B a_220000_1778800# a_755714_1778800# RPP W=2.4e-06 L=0.000267857
XR242A a_787114_1784800# a_790714_1784800# RPP W=2.4e-06 L=0.000267857
XR242B a_790714_1784800# a_1326428_1778800# RPP W=2.4e-06 L=0.000267857
XR243A a_216400_1784800# a_220000_1784800# RPP W=2.4e-06 L=0.000267857
XR243B a_220000_1784800# a_755714_1778800# RPP W=2.4e-06 L=0.000267857
XR244A a_787114_1784800# a_790714_1790800# RPP W=2.4e-06 L=0.000267857
XR244B a_790714_1790800# a_1326428_1790800# RPP W=2.4e-06 L=0.000267857
XR245A a_216400_1784800# a_220000_1790800# RPP W=2.4e-06 L=0.000267857
XR245B a_220000_1790800# a_755714_1790800# RPP W=2.4e-06 L=0.000267857
XR246A a_787114_1796800# a_790714_1796800# RPP W=2.4e-06 L=0.000267857
XR246B a_790714_1796800# a_1326428_1790800# RPP W=2.4e-06 L=0.000267857
XR247A a_216400_1796800# a_220000_1796800# RPP W=2.4e-06 L=0.000267857
XR247B a_220000_1796800# a_755714_1790800# RPP W=2.4e-06 L=0.000267857
XR248A a_787114_1796800# a_790714_1802800# RPP W=2.4e-06 L=0.000267857
XR248B a_790714_1802800# a_1326428_1802800# RPP W=2.4e-06 L=0.000267857
XR249A a_216400_1796800# a_220000_1802800# RPP W=2.4e-06 L=0.000267857
XR249B a_220000_1802800# a_755714_1802800# RPP W=2.4e-06 L=0.000267857
XR250A a_787114_1808800# a_790714_1808800# RPP W=2.4e-06 L=0.000267857
XR250B a_790714_1808800# a_1326428_1802800# RPP W=2.4e-06 L=0.000267857
XR251A a_216400_1808800# a_220000_1808800# RPP W=2.4e-06 L=0.000267857
XR251B a_220000_1808800# a_755714_1802800# RPP W=2.4e-06 L=0.000267857
XR252A a_787114_1808800# a_790714_1814800# RPP W=2.4e-06 L=0.000267857
XR252B a_790714_1814800# a_1326428_1814800# RPP W=2.4e-06 L=0.000267857
XR253A a_216400_1808800# a_220000_1814800# RPP W=2.4e-06 L=0.000267857
XR253B a_220000_1814800# a_755714_1814800# RPP W=2.4e-06 L=0.000267857
XR254A a_787114_1820800# a_790714_1820800# RPP W=2.4e-06 L=0.000267857
XR254B a_790714_1820800# a_1326428_1814800# RPP W=2.4e-06 L=0.000267857
XR255A a_216400_1820800# a_220000_1820800# RPP W=2.4e-06 L=0.000267857
XR255B a_220000_1820800# a_755714_1814800# RPP W=2.4e-06 L=0.000267857
XR256A a_787114_1820800# a_790714_1826800# RPP W=2.4e-06 L=0.000267857
XR256B a_790714_1826800# a_1326428_1826800# RPP W=2.4e-06 L=0.000267857
XR257A a_216400_1820800# a_220000_1826800# RPP W=2.4e-06 L=0.000267857
XR257B a_220000_1826800# a_755714_1826800# RPP W=2.4e-06 L=0.000267857
XR258A a_787114_1832800# a_790714_1832800# RPP W=2.4e-06 L=0.000267857
XR258B a_790714_1832800# a_1326428_1826800# RPP W=2.4e-06 L=0.000267857
XR259A a_216400_1832800# a_220000_1832800# RPP W=2.4e-06 L=0.000267857
XR259B a_220000_1832800# a_755714_1826800# RPP W=2.4e-06 L=0.000267857
XR260A a_787114_1832800# a_790714_1838800# RPP W=2.4e-06 L=0.000267857
XR260B a_790714_1838800# a_1326428_1838800# RPP W=2.4e-06 L=0.000267857
XR261A a_216400_1832800# a_220000_1838800# RPP W=2.4e-06 L=0.000267857
XR261B a_220000_1838800# a_755714_1838800# RPP W=2.4e-06 L=0.000267857
XR262A a_787114_1844800# a_790714_1844800# RPP W=2.4e-06 L=0.000267857
XR262B a_790714_1844800# a_1326428_1838800# RPP W=2.4e-06 L=0.000267857
XR263A a_216400_1844800# a_220000_1844800# RPP W=2.4e-06 L=0.000267857
XR263B a_220000_1844800# a_755714_1838800# RPP W=2.4e-06 L=0.000267857
XR264A a_787114_1844800# a_790714_1850800# RPP W=2.4e-06 L=0.000267857
XR264B a_790714_1850800# a_1326428_1850800# RPP W=2.4e-06 L=0.000267857
XR265A a_216400_1844800# a_220000_1850800# RPP W=2.4e-06 L=0.000267857
XR265B a_220000_1850800# a_755714_1850800# RPP W=2.4e-06 L=0.000267857
XR266A a_787114_1856800# a_790714_1856800# RPP W=2.4e-06 L=0.000267857
XR266B a_790714_1856800# a_1326428_1850800# RPP W=2.4e-06 L=0.000267857
XR267A a_216400_1856800# a_220000_1856800# RPP W=2.4e-06 L=0.000267857
XR267B a_220000_1856800# a_755714_1850800# RPP W=2.4e-06 L=0.000267857
XR268A a_787114_1856800# a_790714_1862800# RPP W=2.4e-06 L=0.000267857
XR268B a_790714_1862800# a_1326428_1862800# RPP W=2.4e-06 L=0.000267857
XR269A a_216400_1856800# a_220000_1862800# RPP W=2.4e-06 L=0.000267857
XR269B a_220000_1862800# a_755714_1862800# RPP W=2.4e-06 L=0.000267857
XR270A a_787114_1868800# a_790714_1868800# RPP W=2.4e-06 L=0.000267857
XR270B a_790714_1868800# a_1326428_1862800# RPP W=2.4e-06 L=0.000267857
XR271A a_216400_1868800# a_220000_1868800# RPP W=2.4e-06 L=0.000267857
XR271B a_220000_1868800# a_755714_1862800# RPP W=2.4e-06 L=0.000267857
XR272A a_787114_1868800# a_790714_1874800# RPP W=2.4e-06 L=0.000267857
XR272B a_790714_1874800# a_1326428_1874800# RPP W=2.4e-06 L=0.000267857
XR273A a_216400_1868800# a_220000_1874800# RPP W=2.4e-06 L=0.000267857
XR273B a_220000_1874800# a_755714_1874800# RPP W=2.4e-06 L=0.000267857
XR274A a_787114_1880800# a_790714_1880800# RPP W=2.4e-06 L=0.000267857
XR274B a_790714_1880800# a_1326428_1874800# RPP W=2.4e-06 L=0.000267857
XR275A a_216400_1880800# a_220000_1880800# RPP W=2.4e-06 L=0.000267857
XR275B a_220000_1880800# a_755714_1874800# RPP W=2.4e-06 L=0.000267857
XR276A a_787114_1880800# a_790714_1886800# RPP W=2.4e-06 L=0.000267857
XR276B a_790714_1886800# a_1326428_1886800# RPP W=2.4e-06 L=0.000267857
XR277A a_216400_1880800# a_220000_1886800# RPP W=2.4e-06 L=0.000267857
XR277B a_220000_1886800# a_755714_1886800# RPP W=2.4e-06 L=0.000267857
XR278A a_787114_1892800# a_790714_1892800# RPP W=2.4e-06 L=0.000267857
XR278B a_790714_1892800# a_1326428_1886800# RPP W=2.4e-06 L=0.000267857
XR279A a_216400_1892800# a_220000_1892800# RPP W=2.4e-06 L=0.000267857
XR279B a_220000_1892800# a_755714_1886800# RPP W=2.4e-06 L=0.000267857
XR280A a_787114_1892800# a_790714_1898800# RPP W=2.4e-06 L=0.000267857
XR280B a_790714_1898800# a_1326428_1898800# RPP W=2.4e-06 L=0.000267857
XR281A a_216400_1892800# a_220000_1898800# RPP W=2.4e-06 L=0.000267857
XR281B a_220000_1898800# a_755714_1898800# RPP W=2.4e-06 L=0.000267857
XR282A a_787114_1904800# a_790714_1904800# RPP W=2.4e-06 L=0.000267857
XR282B a_790714_1904800# a_1326428_1898800# RPP W=2.4e-06 L=0.000267857
XR283A a_216400_1904800# a_220000_1904800# RPP W=2.4e-06 L=0.000267857
XR283B a_220000_1904800# a_755714_1898800# RPP W=2.4e-06 L=0.000267857
XR284A a_787114_1904800# a_790714_1910800# RPP W=2.4e-06 L=0.000267857
XR284B a_790714_1910800# a_1326428_1910800# RPP W=2.4e-06 L=0.000267857
XR285A a_216400_1904800# a_220000_1910800# RPP W=2.4e-06 L=0.000267857
XR285B a_220000_1910800# a_755714_1910800# RPP W=2.4e-06 L=0.000267857
XR286A a_787114_1916800# a_790714_1916800# RPP W=2.4e-06 L=0.000267857
XR286B a_790714_1916800# a_1326428_1910800# RPP W=2.4e-06 L=0.000267857
XR287A a_216400_1916800# a_220000_1916800# RPP W=2.4e-06 L=0.000267857
XR287B a_220000_1916800# a_755714_1910800# RPP W=2.4e-06 L=0.000267857
XR288A a_787114_1916800# a_790714_1922800# RPP W=2.4e-06 L=0.000267857
XR288B a_790714_1922800# a_1326428_1922800# RPP W=2.4e-06 L=0.000267857
XR289A a_216400_1916800# a_220000_1922800# RPP W=2.4e-06 L=0.000267857
XR289B a_220000_1922800# a_755714_1922800# RPP W=2.4e-06 L=0.000267857
XR290A a_787114_1928800# a_790714_1928800# RPP W=2.4e-06 L=0.000267857
XR290B a_790714_1928800# a_1326428_1922800# RPP W=2.4e-06 L=0.000267857
XR291A a_216400_1928800# a_220000_1928800# RPP W=2.4e-06 L=0.000267857
XR291B a_220000_1928800# a_755714_1922800# RPP W=2.4e-06 L=0.000267857
XR292A a_787114_1928800# a_790714_1934800# RPP W=2.4e-06 L=0.000267857
XR292B a_790714_1934800# a_1326428_1934800# RPP W=2.4e-06 L=0.000267857
XR293A a_216400_1928800# a_220000_1934800# RPP W=2.4e-06 L=0.000267857
XR293B a_220000_1934800# a_755714_1934800# RPP W=2.4e-06 L=0.000267857
XR294A a_787114_1940800# a_790714_1940800# RPP W=2.4e-06 L=0.000267857
XR294B a_790714_1940800# a_1326428_1934800# RPP W=2.4e-06 L=0.000267857
XR295A a_216400_1940800# a_220000_1940800# RPP W=2.4e-06 L=0.000267857
XR295B a_220000_1940800# a_755714_1934800# RPP W=2.4e-06 L=0.000267857
XR296A a_787114_1940800# a_790714_1946800# RPP W=2.4e-06 L=0.000267857
XR296B a_790714_1946800# a_1326428_1946800# RPP W=2.4e-06 L=0.000267857
XR297A a_216400_1940800# a_220000_1946800# RPP W=2.4e-06 L=0.000267857
XR297B a_220000_1946800# a_755714_1946800# RPP W=2.4e-06 L=0.000267857
XR298A a_787114_1952800# a_790714_1952800# RPP W=2.4e-06 L=0.000267857
XR298B a_790714_1952800# a_1326428_1946800# RPP W=2.4e-06 L=0.000267857
XR299A a_216400_1952800# a_220000_1952800# RPP W=2.4e-06 L=0.000267857
XR299B a_220000_1952800# a_755714_1946800# RPP W=2.4e-06 L=0.000267857
XR300A a_787114_1952800# a_790714_1958800# RPP W=2.4e-06 L=0.000267857
XR300B a_790714_1958800# a_1326428_1958800# RPP W=2.4e-06 L=0.000267857
XR301A a_216400_1952800# a_220000_1958800# RPP W=2.4e-06 L=0.000267857
XR301B a_220000_1958800# a_755714_1958800# RPP W=2.4e-06 L=0.000267857
XR302A a_787114_1964800# a_790714_1964800# RPP W=2.4e-06 L=0.000267857
XR302B a_790714_1964800# a_1326428_1958800# RPP W=2.4e-06 L=0.000267857
XR303A a_216400_1964800# a_220000_1964800# RPP W=2.4e-06 L=0.000267857
XR303B a_220000_1964800# a_755714_1958800# RPP W=2.4e-06 L=0.000267857
XR304A a_787114_1964800# a_790714_1970800# RPP W=2.4e-06 L=0.000267857
XR304B a_790714_1970800# a_1326428_1970800# RPP W=2.4e-06 L=0.000267857
XR305A a_216400_1964800# a_220000_1970800# RPP W=2.4e-06 L=0.000267857
XR305B a_220000_1970800# a_755714_1970800# RPP W=2.4e-06 L=0.000267857
XR306A a_787114_1976800# a_790714_1976800# RPP W=2.4e-06 L=0.000267857
XR306B a_790714_1976800# a_1326428_1970800# RPP W=2.4e-06 L=0.000267857
XR307A a_216400_1976800# a_220000_1976800# RPP W=2.4e-06 L=0.000267857
XR307B a_220000_1976800# a_755714_1970800# RPP W=2.4e-06 L=0.000267857
XR308A a_787114_1976800# a_790714_1982800# RPP W=2.4e-06 L=0.000267857
XR308B a_790714_1982800# a_1326428_1982800# RPP W=2.4e-06 L=0.000267857
XR309A a_216400_1976800# a_220000_1982800# RPP W=2.4e-06 L=0.000267857
XR309B a_220000_1982800# a_755714_1982800# RPP W=2.4e-06 L=0.000267857
XR310A a_787114_1988800# a_790714_1988800# RPP W=2.4e-06 L=0.000267857
XR310B a_790714_1988800# a_1326428_1982800# RPP W=2.4e-06 L=0.000267857
XR311A a_216400_1988800# a_220000_1988800# RPP W=2.4e-06 L=0.000267857
XR311B a_220000_1988800# a_755714_1982800# RPP W=2.4e-06 L=0.000267857
XR312A a_787114_1988800# a_790714_1994800# RPP W=2.4e-06 L=0.000267857
XR312B a_790714_1994800# a_1326428_1994800# RPP W=2.4e-06 L=0.000267857
XR313A a_216400_1988800# a_220000_1994800# RPP W=2.4e-06 L=0.000267857
XR313B a_220000_1994800# a_755714_1994800# RPP W=2.4e-06 L=0.000267857
XR314A a_787114_2000800# a_790714_2000800# RPP W=2.4e-06 L=0.000267857
XR314B a_790714_2000800# a_1326428_1994800# RPP W=2.4e-06 L=0.000267857
XR315A a_216400_2000800# a_220000_2000800# RPP W=2.4e-06 L=0.000267857
XR315B a_220000_2000800# a_755714_1994800# RPP W=2.4e-06 L=0.000267857
XR316A a_787114_2000800# a_790714_2006800# RPP W=2.4e-06 L=0.000267857
XR316B a_790714_2006800# a_1326428_2006800# RPP W=2.4e-06 L=0.000267857
XR317A a_216400_2000800# a_220000_2006800# RPP W=2.4e-06 L=0.000267857
XR317B a_220000_2006800# a_755714_2006800# RPP W=2.4e-06 L=0.000267857
XR318A a_216400_2012800# a_790714_2012800# RPP W=2.4e-06 L=0.000267857
XR318B a_790714_2012800# a_1326428_2006800# RPP W=2.4e-06 L=0.000267857
XR319A a_216400_2012800# a_220000_2012800# RPP W=2.4e-06 L=0.000267857
XR319B a_220000_2012800# a_755714_2006800# RPP W=2.4e-06 L=0.000267857
.ends
