* Extracted by KLayout with SCL C1D LVS runset on : 20/11/2026 19:24

* cell ota_boosted_layout
* pin INP
* pin INN
* pin OUTP
* pin OUTM
* pin VDD
* pin IREF
* pin VCM
* pin NBOOST
* pin PBOOST
* pin VSS
.SUBCKT ota_boosted_layout INP INN OUTP OUTM VDD IREF VCM NBOOST PBOOST VSS
* device instance $1 r0 *1 294,996.714 N
M$1 \$36 IREF VSS VSS N L=3.2U W=11.429U AS=51.4305P AD=51.4305P PS=31.858U
+ PD=31.858U
* device instance $2 r0 *1 256.8,996.714 N
M$2 \$22 IREF VSS VSS N L=3.2U W=11.429U AS=51.4305P AD=51.4305P PS=31.858U
+ PD=31.858U
* device instance $3 r0 *1 363.2,919.4 N
M$3 \$34 \$35 \$36 VSS N L=2.4U W=10U AS=45P AD=45P PS=29U PD=29U
* device instance $4 r0 *1 327.2,919.4 N
M$4 \$15 \$33 VSS VSS N L=1.6U W=10U AS=45P AD=45P PS=29U PD=29U
* device instance $5 r0 *1 256.4,83.7 N
M$5 \$9 INP \$8 VSS N L=2.4U W=15U AS=67.5P AD=67.5P PS=39U PD=39U
* device instance $6 r0 *1 292.8,83.7 N
M$6 \$10 INN \$8 VSS N L=2.4U W=15U AS=67.5P AD=67.5P PS=39U PD=39U
* device instance $7 r0 *1 291.6,919.4 N
M$7 \$33 \$33 VSS VSS N L=1.6U W=10U AS=45P AD=45P PS=29U PD=29U
* device instance $8 r0 *1 365.6,91.2 N
M$8 OUTP \$12 \$10 VSS N L=2.4U W=30U AS=135P AD=135P PS=69U PD=69U
* device instance $9 r0 *1 329.2,91.2 N
M$9 OUTM \$11 \$9 VSS N L=2.4U W=30U AS=135P AD=135P PS=69U PD=69U
* device instance $10 r0 *1 219.6,116.2 N
M$10 \$8 IREF VSS VSS N L=3.2U W=80U AS=360P AD=360P PS=169U PD=169U
* device instance $11 r0 *1 399.6,919.4 N
M$11 \$17 \$21 \$36 VSS N L=2.4U W=10U AS=45P AD=45P PS=29U PD=29U
* device instance $12 r0 *1 362.8,818.8 N
M$12 \$13 \$31 VSS VSS N L=1.6U W=10U AS=45P AD=45P PS=29U PD=29U
* device instance $13 r0 *1 330.4,242 N
M$13 IREF IREF VSS VSS N L=3.2U W=20U AS=90P AD=90P PS=49U PD=49U
* device instance $14 r0 *1 398.4,641.6 N
M$14 \$12 \$10 \$26 VSS N L=1.6U W=10U AS=45P AD=45P PS=29U PD=29U
* device instance $15 r0 *1 218.8,641.6 N
M$15 \$11 \$9 \$24 VSS N L=1.6U W=10U AS=45P AD=45P PS=29U PD=29U
* device instance $16 r0 *1 400.8,728 N
M$16 \$28 IREF VSS VSS N L=3.2U W=20U AS=90P AD=90P PS=49U PD=49U
* device instance $17 r0 *1 327.2,818.8 N
M$17 \$31 \$31 VSS VSS N L=1.6U W=10U AS=45P AD=45P PS=29U PD=29U
* device instance $18 r0 *1 218.8,723 N
M$18 \$27 NBOOST \$26 VSS N L=1.6U W=10U AS=45P AD=45P PS=29U PD=29U
* device instance $19 r0 *1 290.8,642.314 N
M$19 \$24 IREF VSS VSS N L=3.2U W=11.429U AS=51.4305P AD=51.4305P PS=31.858U
+ PD=31.858U
* device instance $20 r0 *1 254.4,641.6 N
M$20 \$25 NBOOST \$24 VSS N L=1.6U W=10U AS=45P AD=45P PS=29U PD=29U
* device instance $21 r0 *1 255.2,723.714 N
M$21 \$26 IREF VSS VSS N L=3.2U W=11.429U AS=51.4305P AD=51.4305P PS=31.858U
+ PD=31.858U
* device instance $22 r0 *1 402,106.2 P
M$22 OUTM \$13 \$14 VDD P L=2.4U W=60U AS=270P AD=270P PS=129U PD=129U
* device instance $23 r0 *1 219.2,262 P
M$23 OUTP \$15 \$16 VDD P L=2.4U W=60U AS=270P AD=270P PS=129U PD=129U
* device instance $24 r0 *1 256,252 P
M$24 \$14 \$17 VDD VDD P L=3.2U W=40U AS=180P AD=180P PS=89U PD=89U
* device instance $25 r0 *1 293.2,252 P
M$25 \$16 \$17 VDD VDD P L=3.2U W=40U AS=180P AD=180P PS=89U PD=89U
* device instance $26 r0 *1 366.8,252 P
M$26 VSS OUTP \$18 VDD P L=1.6U W=40U AS=180P AD=180P PS=89U PD=89U
* device instance $27 r0 *1 402.4,252 P
M$27 VSS OUTM \$19 VDD P L=1.6U W=40U AS=180P AD=180P PS=89U PD=89U
* device instance $28 r0 *1 218.8,373.4 P
M$28 VSS VCM \$21 VDD P L=1.6U W=40U AS=180P AD=180P PS=89U PD=89U
* device instance $29 r0 *1 255.2,373.4 P
M$29 \$18 \$22 VDD VDD P L=3.2U W=40U AS=180P AD=180P PS=89U PD=89U
* device instance $30 r0 *1 292.4,373.4 P
M$30 \$19 \$22 VDD VDD P L=3.2U W=40U AS=180P AD=180P PS=89U PD=89U
* device instance $31 r0 *1 329.6,373.4 P
M$31 \$21 \$22 VDD VDD P L=3.2U W=40U AS=180P AD=180P PS=89U PD=89U
* device instance $32 r0 *1 370.2,363.4 P
M$32 VDD \$17 VDD VDD P L=10U W=80U AS=360P AD=360P PS=196U PD=196U
* device instance $36 r0 *1 311,440.8 P
M$36 OUTP \$17 OUTP OUTP P L=10U W=160U AS=720P AD=720P PS=392U PD=392U
* device instance $44 r0 *1 399,498.2 P
M$44 OUTM \$17 OUTM OUTM P L=10U W=160U AS=720P AD=720P PS=392U PD=392U
* device instance $52 r0 *1 218.8,823.8 P
M$52 \$13 \$14 \$30 VDD P L=1.6U W=20U AS=90P AD=90P PS=49U PD=49U
* device instance $53 r0 *1 254.4,823.8 P
M$53 \$31 PBOOST \$30 VDD P L=1.6U W=20U AS=90P AD=90P PS=49U PD=49U
* device instance $54 r0 *1 290.8,819.514 P
M$54 \$30 \$28 VDD VDD P L=3.2U W=11.429U AS=51.4305P AD=51.4305P PS=31.858U
+ PD=31.858U
* device instance $55 r0 *1 291.6,728 P
M$55 \$27 \$27 VDD VDD P L=1.6U W=20U AS=90P AD=90P PS=49U PD=49U
* device instance $56 r0 *1 327.2,646.6 P
M$56 \$25 \$25 VDD VDD P L=1.6U W=20U AS=90P AD=90P PS=49U PD=49U
* device instance $57 r0 *1 327.2,728 P
M$57 \$12 \$27 VDD VDD P L=1.6U W=20U AS=90P AD=90P PS=49U PD=49U
* device instance $58 r0 *1 363.6,728 P
M$58 \$28 \$28 VDD VDD P L=3.2U W=20U AS=90P AD=90P PS=49U PD=49U
* device instance $59 r0 *1 362.8,646.6 P
M$59 \$11 \$25 VDD VDD P L=1.6U W=20U AS=90P AD=90P PS=49U PD=49U
* device instance $60 r0 *1 398.4,823.8 P
M$60 \$15 \$16 \$32 VDD P L=1.6U W=20U AS=90P AD=90P PS=49U PD=49U
* device instance $61 r0 *1 219.6,1001 P
M$61 \$22 \$22 VDD VDD P L=3.2U W=20U AS=90P AD=90P PS=49U PD=49U
* device instance $62 r0 *1 218.8,924.4 P
M$62 \$33 PBOOST \$32 VDD P L=1.6U W=20U AS=90P AD=90P PS=49U PD=49U
* device instance $63 r0 *1 255.2,920.114 P
M$63 \$32 \$28 VDD VDD P L=3.2U W=11.429U AS=51.4305P AD=51.4305P PS=31.858U
+ PD=31.858U
* device instance $64 r0 *1 331.2,1001 P
M$64 \$34 \$34 VDD VDD P L=3.2U W=20U AS=90P AD=90P PS=49U PD=49U
* device instance $65 r0 *1 368.4,1001 P
M$65 \$17 \$34 VDD VDD P L=3.2U W=20U AS=90P AD=90P PS=49U PD=49U
* device instance $384 r0 *1 487.857,2014 RPP
R$384 \$35 \$18 999999.466667 RPP
* device instance $385 r0 *1 1058.571,2014 RPP
R$385 \$35 \$19 999999.466667 RPP
.ENDS ota_boosted_layout
