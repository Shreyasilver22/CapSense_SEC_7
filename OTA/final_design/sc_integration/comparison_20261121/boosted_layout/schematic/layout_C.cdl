* NGSPICE file created from ota_boosted_layout.ext - technology: SCL_CP8D

.subckt ota_boosted_layout INP INN OUTP OUTM VDD VSS IREF VCM NBOOST PBOOST
M1000 a_329600_989500# a_329600_989500# VDD VDD P w=20u l=3.2u
+  ad=90p pd=49u as=-1852.11p ps=1292.72u
M1001 a_218000_989500# IREF VSS VSS N w=11.429u l=3.2u
+  ad=51.4305p pd=31.858u as=925.722p ps=510.432u
M1002 a_213500_636600# IREF VSS VSS N w=11.429u l=3.2u
+  ad=141.431p pd=89.858u as=0p ps=0u
M1003 OUTM a_218000_429300# OUTM OUTM P w=20u l=10u
+  ad=1710p pd=913u as=0p ps=0u
M1004 OUTM a_219600_813800# a_217700_835900# VDD P w=60u l=2.4u
+  ad=0p pd=0u as=450p ps=218u
M1005 a_328000_718000# a_219600_718000# VDD VDD P w=20u l=1.6u
+  ad=90p pd=49u as=-0p ps=0u
M1006 a_253600_912900# IREF VSS VSS N w=20u l=3.2u
+  ad=90p pd=49u as=0p ps=0u
M1007 a_213500_232000# a_218000_429300# VDD VDD P w=40u l=3.2u
+  ad=450p pd=218u as=-0p ps=0u
M1008 OUTP a_218000_230500# a_213500_232000# VDD P w=60u l=2.4u
+  ad=1710p pd=913u as=0p ps=0u
M1009 a_294000_353400# a_218000_989500# VDD VDD P w=40u l=3.2u
+  ad=360p pd=178u as=-0p ps=0u
M1010 a_213500_914400# a_253600_912900# VDD VDD P w=11.429u l=3.2u
+  ad=231.431p pd=129.858u as=-0p ps=0u
M1011 a_255200_636600# a_255200_636600# VDD VDD P w=20u l=1.6u
+  ad=90p pd=49u as=-0p ps=0u
M1012 OUTP a_218000_429300# OUTP OUTP P w=20u l=10u
+  ad=0p pd=0u as=0p ps=0u
M1013 a_213500_813800# a_253600_912900# VDD VDD P w=11.429u l=3.2u
+  ad=231.431p pd=129.858u as=-0p ps=0u
M1014 a_217700_648700# INP a_221200_76200# VSS N w=15u l=2.4u
+  ad=202.5p pd=108u as=495p ps=247u
M1015 OUTP a_218000_429300# OUTP OUTP P w=20u l=10u
+  ad=0p pd=0u as=0p ps=0u
M1016 a_218000_429300# a_213500_353400# a_295600_991000# VSS N w=10u l=2.4u
+  ad=45p pd=29u as=141.431p ps=89.858u
M1017 a_219600_914400# PBOOST a_213500_914400# VDD P w=20u l=1.6u
+  ad=90p pd=49u as=0p ps=0u
M1018 a_255200_813800# a_255200_813800# VSS VSS N w=10u l=1.6u
+  ad=45p pd=29u as=0p ps=0u
M1019 IREF IREF VSS VSS N w=20u l=3.2u
+  ad=90p pd=49u as=0p ps=0u
M1020 a_219600_718000# a_219600_718000# VDD VDD P w=20u l=1.6u
+  ad=90p pd=49u as=-0p ps=0u
M1021 a_218000_989500# a_218000_989500# VDD VDD P w=20u l=3.2u
+  ad=90p pd=49u as=-0p ps=0u
M1022 OUTM a_219600_636600# a_217700_648700# VSS N w=30u l=2.4u
+  ad=207p pd=165u as=0p ps=0u
M1023 OUTP a_218000_429300# OUTP OUTP P w=20u l=10u
+  ad=0p pd=0u as=0p ps=0u
M1024 a_253600_912900# a_253600_912900# VDD VDD P w=20u l=3.2u
+  ad=90p pd=49u as=-0p ps=0u
M1025 VDD a_218000_429300# VDD VDD P w=20u l=10u
+  ad=-0p pd=0u as=-0p ps=0u
M1026 VDD a_218000_429300# VDD VDD P w=20u l=10u
+  ad=-0p pd=0u as=-0p ps=0u
M1027 a_328000_718000# a_294000_76200# a_213500_718000# VSS N w=10u l=1.6u
+  ad=45p pd=29u as=141.431p ps=89.858u
M1028 VSS OUTP a_216400_1058800# VDD P w=40u l=1.6u
+  ad=729p pd=519u as=360p ps=178u
M1029 OUTM a_218000_429300# OUTM OUTM P w=20u l=10u
+  ad=0p pd=0u as=0p ps=0u
M1030 VDD a_218000_429300# VDD VDD P w=20u l=10u
+  ad=-0p pd=0u as=-0p ps=0u
M1031 OUTM a_218000_429300# OUTM OUTM P w=20u l=10u
+  ad=0p pd=0u as=0p ps=0u
M1032 a_217700_835900# a_218000_429300# VDD VDD P w=40u l=3.2u
+  ad=0p pd=0u as=-0p ps=0u
M1033 a_219600_636600# a_255200_636600# VDD VDD P w=20u l=1.6u
+  ad=90p pd=49u as=-0p ps=0u
M1034 a_216400_1058800# a_218000_989500# VDD VDD P w=40u l=3.2u
+  ad=0p pd=0u as=-0p ps=0u
M1035 a_221200_76200# IREF VSS VSS N w=80u l=3.2u
+  ad=0p pd=0u as=0p ps=0u
M1036 OUTM a_218000_429300# OUTM OUTM P w=20u l=10u
+  ad=0p pd=0u as=0p ps=0u
M1037 OUTM a_218000_429300# OUTM OUTM P w=20u l=10u
+  ad=0p pd=0u as=0p ps=0u
M1038 a_219600_813800# a_255200_813800# VSS VSS N w=10u l=1.6u
+  ad=45p pd=29u as=0p ps=0u
M1039 VSS VCM a_213500_353400# VDD P w=40u l=1.6u
+  ad=0p pd=0u as=360p ps=178u
M1040 a_218000_230500# a_219600_914400# VSS VSS N w=10u l=1.6u
+  ad=45p pd=29u as=0p ps=0u
M1041 a_213500_718000# IREF VSS VSS N w=11.429u l=3.2u
+  ad=0p pd=0u as=0p ps=0u
M1042 a_218000_230500# a_213500_232000# a_213500_914400# VDD P w=20u l=1.6u
+  ad=90p pd=49u as=0p ps=0u
M1043 a_294000_76200# INN a_221200_76200# VSS N w=15u l=2.4u
+  ad=202.5p pd=108u as=0p ps=0u
M1044 a_255200_636600# NBOOST a_213500_636600# VSS N w=10u l=1.6u
+  ad=45p pd=29u as=0p ps=0u
M1045 a_218000_429300# a_329600_989500# VDD VDD P w=20u l=3.2u
+  ad=90p pd=49u as=-0p ps=0u
M1046 a_219600_718000# NBOOST a_213500_718000# VSS N w=10u l=1.6u
+  ad=45p pd=29u as=0p ps=0u
M1047 a_295600_991000# IREF VSS VSS N w=11.429u l=3.2u
+  ad=0p pd=0u as=0p ps=0u
M1048 a_213500_353400# a_218000_989500# VDD VDD P w=40u l=3.2u
+  ad=0p pd=0u as=-0p ps=0u
M1049 OUTM a_218000_429300# OUTM OUTM P w=20u l=10u
+  ad=0p pd=0u as=0p ps=0u
M1050 VSS OUTM a_294000_353400# VDD P w=40u l=1.6u
+  ad=0p pd=0u as=0p ps=0u
M1051 a_219600_636600# a_217700_648700# a_213500_636600# VSS N w=10u l=1.6u
+  ad=45p pd=29u as=0p ps=0u
M1052 OUTM a_218000_429300# OUTM OUTM P w=20u l=10u
+  ad=0p pd=0u as=0p ps=0u
M1053 OUTP a_328000_718000# a_294000_76200# VSS N w=30u l=2.4u
+  ad=207p pd=165u as=0p ps=0u
M1054 OUTP a_218000_429300# OUTP OUTP P w=20u l=10u
+  ad=0p pd=0u as=0p ps=0u
M1055 OUTP a_218000_429300# OUTP OUTP P w=20u l=10u
+  ad=0p pd=0u as=0p ps=0u
M1056 OUTP a_218000_429300# OUTP OUTP P w=20u l=10u
+  ad=0p pd=0u as=0p ps=0u
M1057 OUTP a_218000_429300# OUTP OUTP P w=20u l=10u
+  ad=0p pd=0u as=0p ps=0u
M1058 a_219600_914400# a_219600_914400# VSS VSS N w=10u l=1.6u
+  ad=45p pd=29u as=0p ps=0u
M1059 OUTP a_218000_429300# OUTP OUTP P w=20u l=10u
+  ad=0p pd=0u as=0p ps=0u
M1060 VDD a_218000_429300# VDD VDD P w=20u l=10u
+  ad=-0p pd=0u as=-0p ps=0u
M1061 a_329600_989500# a_216400_2012800# a_295600_991000# VSS N w=10u l=2.4u
+  ad=45p pd=29u as=0p ps=0u
M1062 a_255200_813800# PBOOST a_213500_813800# VDD P w=20u l=1.6u
+  ad=90p pd=49u as=0p ps=0u
M1063 OUTM a_218000_429300# OUTM OUTM P w=20u l=10u
+  ad=0p pd=0u as=0p ps=0u
M1064 a_219600_813800# a_217700_835900# a_213500_813800# VDD P w=20u l=1.6u
+  ad=90p pd=49u as=0p ps=0u
RXR0A a_294000_353400# a_790714_1058800# 3124.99833333 RPP
RXR0B a_790714_1058800# a_1326428_1058800# 3124.99833333 RPP
RXR1A a_216400_1058800# a_220000_1058800# 3124.99833333 RPP
RXR1B a_220000_1058800# a_755714_1058800# 3124.99833333 RPP
RXR2A a_787114_1064800# a_790714_1064800# 3124.99833333 RPP
RXR2B a_790714_1064800# a_1326428_1058800# 3124.99833333 RPP
RXR3A a_216400_1064800# a_220000_1064800# 3124.99833333 RPP
RXR3B a_220000_1064800# a_755714_1058800# 3124.99833333 RPP
RXR4A a_787114_1064800# a_790714_1070800# 3124.99833333 RPP
RXR4B a_790714_1070800# a_1326428_1070800# 3124.99833333 RPP
RXR5A a_216400_1064800# a_220000_1070800# 3124.99833333 RPP
RXR5B a_220000_1070800# a_755714_1070800# 3124.99833333 RPP
RXR6A a_787114_1076800# a_790714_1076800# 3124.99833333 RPP
RXR6B a_790714_1076800# a_1326428_1070800# 3124.99833333 RPP
RXR7A a_216400_1076800# a_220000_1076800# 3124.99833333 RPP
RXR7B a_220000_1076800# a_755714_1070800# 3124.99833333 RPP
RXR8A a_787114_1076800# a_790714_1082800# 3124.99833333 RPP
RXR8B a_790714_1082800# a_1326428_1082800# 3124.99833333 RPP
RXR9A a_216400_1076800# a_220000_1082800# 3124.99833333 RPP
RXR9B a_220000_1082800# a_755714_1082800# 3124.99833333 RPP
RXR10A a_787114_1088800# a_790714_1088800# 3124.99833333 RPP
RXR10B a_790714_1088800# a_1326428_1082800# 3124.99833333 RPP
RXR11A a_216400_1088800# a_220000_1088800# 3124.99833333 RPP
RXR11B a_220000_1088800# a_755714_1082800# 3124.99833333 RPP
RXR12A a_787114_1088800# a_790714_1094800# 3124.99833333 RPP
RXR12B a_790714_1094800# a_1326428_1094800# 3124.99833333 RPP
RXR13A a_216400_1088800# a_220000_1094800# 3124.99833333 RPP
RXR13B a_220000_1094800# a_755714_1094800# 3124.99833333 RPP
RXR14A a_787114_1100800# a_790714_1100800# 3124.99833333 RPP
RXR14B a_790714_1100800# a_1326428_1094800# 3124.99833333 RPP
RXR15A a_216400_1100800# a_220000_1100800# 3124.99833333 RPP
RXR15B a_220000_1100800# a_755714_1094800# 3124.99833333 RPP
RXR16A a_787114_1100800# a_790714_1106800# 3124.99833333 RPP
RXR16B a_790714_1106800# a_1326428_1106800# 3124.99833333 RPP
RXR17A a_216400_1100800# a_220000_1106800# 3124.99833333 RPP
RXR17B a_220000_1106800# a_755714_1106800# 3124.99833333 RPP
RXR18A a_787114_1112800# a_790714_1112800# 3124.99833333 RPP
RXR18B a_790714_1112800# a_1326428_1106800# 3124.99833333 RPP
RXR19A a_216400_1112800# a_220000_1112800# 3124.99833333 RPP
RXR19B a_220000_1112800# a_755714_1106800# 3124.99833333 RPP
RXR20A a_787114_1112800# a_790714_1118800# 3124.99833333 RPP
RXR20B a_790714_1118800# a_1326428_1118800# 3124.99833333 RPP
RXR21A a_216400_1112800# a_220000_1118800# 3124.99833333 RPP
RXR21B a_220000_1118800# a_755714_1118800# 3124.99833333 RPP
RXR22A a_787114_1124800# a_790714_1124800# 3124.99833333 RPP
RXR22B a_790714_1124800# a_1326428_1118800# 3124.99833333 RPP
RXR23A a_216400_1124800# a_220000_1124800# 3124.99833333 RPP
RXR23B a_220000_1124800# a_755714_1118800# 3124.99833333 RPP
RXR24A a_787114_1124800# a_790714_1130800# 3124.99833333 RPP
RXR24B a_790714_1130800# a_1326428_1130800# 3124.99833333 RPP
RXR25A a_216400_1124800# a_220000_1130800# 3124.99833333 RPP
RXR25B a_220000_1130800# a_755714_1130800# 3124.99833333 RPP
RXR26A a_787114_1136800# a_790714_1136800# 3124.99833333 RPP
RXR26B a_790714_1136800# a_1326428_1130800# 3124.99833333 RPP
RXR27A a_216400_1136800# a_220000_1136800# 3124.99833333 RPP
RXR27B a_220000_1136800# a_755714_1130800# 3124.99833333 RPP
RXR28A a_787114_1136800# a_790714_1142800# 3124.99833333 RPP
RXR28B a_790714_1142800# a_1326428_1142800# 3124.99833333 RPP
RXR29A a_216400_1136800# a_220000_1142800# 3124.99833333 RPP
RXR29B a_220000_1142800# a_755714_1142800# 3124.99833333 RPP
RXR30A a_787114_1148800# a_790714_1148800# 3124.99833333 RPP
RXR30B a_790714_1148800# a_1326428_1142800# 3124.99833333 RPP
RXR31A a_216400_1148800# a_220000_1148800# 3124.99833333 RPP
RXR31B a_220000_1148800# a_755714_1142800# 3124.99833333 RPP
RXR32A a_787114_1148800# a_790714_1154800# 3124.99833333 RPP
RXR32B a_790714_1154800# a_1326428_1154800# 3124.99833333 RPP
RXR33A a_216400_1148800# a_220000_1154800# 3124.99833333 RPP
RXR33B a_220000_1154800# a_755714_1154800# 3124.99833333 RPP
RXR34A a_787114_1160800# a_790714_1160800# 3124.99833333 RPP
RXR34B a_790714_1160800# a_1326428_1154800# 3124.99833333 RPP
RXR35A a_216400_1160800# a_220000_1160800# 3124.99833333 RPP
RXR35B a_220000_1160800# a_755714_1154800# 3124.99833333 RPP
RXR36A a_787114_1160800# a_790714_1166800# 3124.99833333 RPP
RXR36B a_790714_1166800# a_1326428_1166800# 3124.99833333 RPP
RXR37A a_216400_1160800# a_220000_1166800# 3124.99833333 RPP
RXR37B a_220000_1166800# a_755714_1166800# 3124.99833333 RPP
RXR38A a_787114_1172800# a_790714_1172800# 3124.99833333 RPP
RXR38B a_790714_1172800# a_1326428_1166800# 3124.99833333 RPP
RXR39A a_216400_1172800# a_220000_1172800# 3124.99833333 RPP
RXR39B a_220000_1172800# a_755714_1166800# 3124.99833333 RPP
RXR40A a_787114_1172800# a_790714_1178800# 3124.99833333 RPP
RXR40B a_790714_1178800# a_1326428_1178800# 3124.99833333 RPP
RXR41A a_216400_1172800# a_220000_1178800# 3124.99833333 RPP
RXR41B a_220000_1178800# a_755714_1178800# 3124.99833333 RPP
RXR42A a_787114_1184800# a_790714_1184800# 3124.99833333 RPP
RXR42B a_790714_1184800# a_1326428_1178800# 3124.99833333 RPP
RXR43A a_216400_1184800# a_220000_1184800# 3124.99833333 RPP
RXR43B a_220000_1184800# a_755714_1178800# 3124.99833333 RPP
RXR44A a_787114_1184800# a_790714_1190800# 3124.99833333 RPP
RXR44B a_790714_1190800# a_1326428_1190800# 3124.99833333 RPP
RXR45A a_216400_1184800# a_220000_1190800# 3124.99833333 RPP
RXR45B a_220000_1190800# a_755714_1190800# 3124.99833333 RPP
RXR46A a_787114_1196800# a_790714_1196800# 3124.99833333 RPP
RXR46B a_790714_1196800# a_1326428_1190800# 3124.99833333 RPP
RXR47A a_216400_1196800# a_220000_1196800# 3124.99833333 RPP
RXR47B a_220000_1196800# a_755714_1190800# 3124.99833333 RPP
RXR48A a_787114_1196800# a_790714_1202800# 3124.99833333 RPP
RXR48B a_790714_1202800# a_1326428_1202800# 3124.99833333 RPP
RXR49A a_216400_1196800# a_220000_1202800# 3124.99833333 RPP
RXR49B a_220000_1202800# a_755714_1202800# 3124.99833333 RPP
RXR50A a_787114_1208800# a_790714_1208800# 3124.99833333 RPP
RXR50B a_790714_1208800# a_1326428_1202800# 3124.99833333 RPP
RXR51A a_216400_1208800# a_220000_1208800# 3124.99833333 RPP
RXR51B a_220000_1208800# a_755714_1202800# 3124.99833333 RPP
RXR52A a_787114_1208800# a_790714_1214800# 3124.99833333 RPP
RXR52B a_790714_1214800# a_1326428_1214800# 3124.99833333 RPP
RXR53A a_216400_1208800# a_220000_1214800# 3124.99833333 RPP
RXR53B a_220000_1214800# a_755714_1214800# 3124.99833333 RPP
RXR54A a_787114_1220800# a_790714_1220800# 3124.99833333 RPP
RXR54B a_790714_1220800# a_1326428_1214800# 3124.99833333 RPP
RXR55A a_216400_1220800# a_220000_1220800# 3124.99833333 RPP
RXR55B a_220000_1220800# a_755714_1214800# 3124.99833333 RPP
RXR56A a_787114_1220800# a_790714_1226800# 3124.99833333 RPP
RXR56B a_790714_1226800# a_1326428_1226800# 3124.99833333 RPP
RXR57A a_216400_1220800# a_220000_1226800# 3124.99833333 RPP
RXR57B a_220000_1226800# a_755714_1226800# 3124.99833333 RPP
RXR58A a_787114_1232800# a_790714_1232800# 3124.99833333 RPP
RXR58B a_790714_1232800# a_1326428_1226800# 3124.99833333 RPP
RXR59A a_216400_1232800# a_220000_1232800# 3124.99833333 RPP
RXR59B a_220000_1232800# a_755714_1226800# 3124.99833333 RPP
RXR60A a_787114_1232800# a_790714_1238800# 3124.99833333 RPP
RXR60B a_790714_1238800# a_1326428_1238800# 3124.99833333 RPP
RXR61A a_216400_1232800# a_220000_1238800# 3124.99833333 RPP
RXR61B a_220000_1238800# a_755714_1238800# 3124.99833333 RPP
RXR62A a_787114_1244800# a_790714_1244800# 3124.99833333 RPP
RXR62B a_790714_1244800# a_1326428_1238800# 3124.99833333 RPP
RXR63A a_216400_1244800# a_220000_1244800# 3124.99833333 RPP
RXR63B a_220000_1244800# a_755714_1238800# 3124.99833333 RPP
RXR64A a_787114_1244800# a_790714_1250800# 3124.99833333 RPP
RXR64B a_790714_1250800# a_1326428_1250800# 3124.99833333 RPP
RXR65A a_216400_1244800# a_220000_1250800# 3124.99833333 RPP
RXR65B a_220000_1250800# a_755714_1250800# 3124.99833333 RPP
RXR66A a_787114_1256800# a_790714_1256800# 3124.99833333 RPP
RXR66B a_790714_1256800# a_1326428_1250800# 3124.99833333 RPP
RXR67A a_216400_1256800# a_220000_1256800# 3124.99833333 RPP
RXR67B a_220000_1256800# a_755714_1250800# 3124.99833333 RPP
RXR68A a_787114_1256800# a_790714_1262800# 3124.99833333 RPP
RXR68B a_790714_1262800# a_1326428_1262800# 3124.99833333 RPP
RXR69A a_216400_1256800# a_220000_1262800# 3124.99833333 RPP
RXR69B a_220000_1262800# a_755714_1262800# 3124.99833333 RPP
RXR70A a_787114_1268800# a_790714_1268800# 3124.99833333 RPP
RXR70B a_790714_1268800# a_1326428_1262800# 3124.99833333 RPP
RXR71A a_216400_1268800# a_220000_1268800# 3124.99833333 RPP
RXR71B a_220000_1268800# a_755714_1262800# 3124.99833333 RPP
RXR72A a_787114_1268800# a_790714_1274800# 3124.99833333 RPP
RXR72B a_790714_1274800# a_1326428_1274800# 3124.99833333 RPP
RXR73A a_216400_1268800# a_220000_1274800# 3124.99833333 RPP
RXR73B a_220000_1274800# a_755714_1274800# 3124.99833333 RPP
RXR74A a_787114_1280800# a_790714_1280800# 3124.99833333 RPP
RXR74B a_790714_1280800# a_1326428_1274800# 3124.99833333 RPP
RXR75A a_216400_1280800# a_220000_1280800# 3124.99833333 RPP
RXR75B a_220000_1280800# a_755714_1274800# 3124.99833333 RPP
RXR76A a_787114_1280800# a_790714_1286800# 3124.99833333 RPP
RXR76B a_790714_1286800# a_1326428_1286800# 3124.99833333 RPP
RXR77A a_216400_1280800# a_220000_1286800# 3124.99833333 RPP
RXR77B a_220000_1286800# a_755714_1286800# 3124.99833333 RPP
RXR78A a_787114_1292800# a_790714_1292800# 3124.99833333 RPP
RXR78B a_790714_1292800# a_1326428_1286800# 3124.99833333 RPP
RXR79A a_216400_1292800# a_220000_1292800# 3124.99833333 RPP
RXR79B a_220000_1292800# a_755714_1286800# 3124.99833333 RPP
RXR80A a_787114_1292800# a_790714_1298800# 3124.99833333 RPP
RXR80B a_790714_1298800# a_1326428_1298800# 3124.99833333 RPP
RXR81A a_216400_1292800# a_220000_1298800# 3124.99833333 RPP
RXR81B a_220000_1298800# a_755714_1298800# 3124.99833333 RPP
RXR82A a_787114_1304800# a_790714_1304800# 3124.99833333 RPP
RXR82B a_790714_1304800# a_1326428_1298800# 3124.99833333 RPP
RXR83A a_216400_1304800# a_220000_1304800# 3124.99833333 RPP
RXR83B a_220000_1304800# a_755714_1298800# 3124.99833333 RPP
RXR84A a_787114_1304800# a_790714_1310800# 3124.99833333 RPP
RXR84B a_790714_1310800# a_1326428_1310800# 3124.99833333 RPP
RXR85A a_216400_1304800# a_220000_1310800# 3124.99833333 RPP
RXR85B a_220000_1310800# a_755714_1310800# 3124.99833333 RPP
RXR86A a_787114_1316800# a_790714_1316800# 3124.99833333 RPP
RXR86B a_790714_1316800# a_1326428_1310800# 3124.99833333 RPP
RXR87A a_216400_1316800# a_220000_1316800# 3124.99833333 RPP
RXR87B a_220000_1316800# a_755714_1310800# 3124.99833333 RPP
RXR88A a_787114_1316800# a_790714_1322800# 3124.99833333 RPP
RXR88B a_790714_1322800# a_1326428_1322800# 3124.99833333 RPP
RXR89A a_216400_1316800# a_220000_1322800# 3124.99833333 RPP
RXR89B a_220000_1322800# a_755714_1322800# 3124.99833333 RPP
RXR90A a_787114_1328800# a_790714_1328800# 3124.99833333 RPP
RXR90B a_790714_1328800# a_1326428_1322800# 3124.99833333 RPP
RXR91A a_216400_1328800# a_220000_1328800# 3124.99833333 RPP
RXR91B a_220000_1328800# a_755714_1322800# 3124.99833333 RPP
RXR92A a_787114_1328800# a_790714_1334800# 3124.99833333 RPP
RXR92B a_790714_1334800# a_1326428_1334800# 3124.99833333 RPP
RXR93A a_216400_1328800# a_220000_1334800# 3124.99833333 RPP
RXR93B a_220000_1334800# a_755714_1334800# 3124.99833333 RPP
RXR94A a_787114_1340800# a_790714_1340800# 3124.99833333 RPP
RXR94B a_790714_1340800# a_1326428_1334800# 3124.99833333 RPP
RXR95A a_216400_1340800# a_220000_1340800# 3124.99833333 RPP
RXR95B a_220000_1340800# a_755714_1334800# 3124.99833333 RPP
RXR96A a_787114_1340800# a_790714_1346800# 3124.99833333 RPP
RXR96B a_790714_1346800# a_1326428_1346800# 3124.99833333 RPP
RXR97A a_216400_1340800# a_220000_1346800# 3124.99833333 RPP
RXR97B a_220000_1346800# a_755714_1346800# 3124.99833333 RPP
RXR98A a_787114_1352800# a_790714_1352800# 3124.99833333 RPP
RXR98B a_790714_1352800# a_1326428_1346800# 3124.99833333 RPP
RXR99A a_216400_1352800# a_220000_1352800# 3124.99833333 RPP
RXR99B a_220000_1352800# a_755714_1346800# 3124.99833333 RPP
RXR100A a_787114_1352800# a_790714_1358800# 3124.99833333 RPP
RXR100B a_790714_1358800# a_1326428_1358800# 3124.99833333 RPP
RXR101A a_216400_1352800# a_220000_1358800# 3124.99833333 RPP
RXR101B a_220000_1358800# a_755714_1358800# 3124.99833333 RPP
RXR102A a_787114_1364800# a_790714_1364800# 3124.99833333 RPP
RXR102B a_790714_1364800# a_1326428_1358800# 3124.99833333 RPP
RXR103A a_216400_1364800# a_220000_1364800# 3124.99833333 RPP
RXR103B a_220000_1364800# a_755714_1358800# 3124.99833333 RPP
RXR104A a_787114_1364800# a_790714_1370800# 3124.99833333 RPP
RXR104B a_790714_1370800# a_1326428_1370800# 3124.99833333 RPP
RXR105A a_216400_1364800# a_220000_1370800# 3124.99833333 RPP
RXR105B a_220000_1370800# a_755714_1370800# 3124.99833333 RPP
RXR106A a_787114_1376800# a_790714_1376800# 3124.99833333 RPP
RXR106B a_790714_1376800# a_1326428_1370800# 3124.99833333 RPP
RXR107A a_216400_1376800# a_220000_1376800# 3124.99833333 RPP
RXR107B a_220000_1376800# a_755714_1370800# 3124.99833333 RPP
RXR108A a_787114_1376800# a_790714_1382800# 3124.99833333 RPP
RXR108B a_790714_1382800# a_1326428_1382800# 3124.99833333 RPP
RXR109A a_216400_1376800# a_220000_1382800# 3124.99833333 RPP
RXR109B a_220000_1382800# a_755714_1382800# 3124.99833333 RPP
RXR110A a_787114_1388800# a_790714_1388800# 3124.99833333 RPP
RXR110B a_790714_1388800# a_1326428_1382800# 3124.99833333 RPP
RXR111A a_216400_1388800# a_220000_1388800# 3124.99833333 RPP
RXR111B a_220000_1388800# a_755714_1382800# 3124.99833333 RPP
RXR112A a_787114_1388800# a_790714_1394800# 3124.99833333 RPP
RXR112B a_790714_1394800# a_1326428_1394800# 3124.99833333 RPP
RXR113A a_216400_1388800# a_220000_1394800# 3124.99833333 RPP
RXR113B a_220000_1394800# a_755714_1394800# 3124.99833333 RPP
RXR114A a_787114_1400800# a_790714_1400800# 3124.99833333 RPP
RXR114B a_790714_1400800# a_1326428_1394800# 3124.99833333 RPP
RXR115A a_216400_1400800# a_220000_1400800# 3124.99833333 RPP
RXR115B a_220000_1400800# a_755714_1394800# 3124.99833333 RPP
RXR116A a_787114_1400800# a_790714_1406800# 3124.99833333 RPP
RXR116B a_790714_1406800# a_1326428_1406800# 3124.99833333 RPP
RXR117A a_216400_1400800# a_220000_1406800# 3124.99833333 RPP
RXR117B a_220000_1406800# a_755714_1406800# 3124.99833333 RPP
RXR118A a_787114_1412800# a_790714_1412800# 3124.99833333 RPP
RXR118B a_790714_1412800# a_1326428_1406800# 3124.99833333 RPP
RXR119A a_216400_1412800# a_220000_1412800# 3124.99833333 RPP
RXR119B a_220000_1412800# a_755714_1406800# 3124.99833333 RPP
RXR120A a_787114_1412800# a_790714_1418800# 3124.99833333 RPP
RXR120B a_790714_1418800# a_1326428_1418800# 3124.99833333 RPP
RXR121A a_216400_1412800# a_220000_1418800# 3124.99833333 RPP
RXR121B a_220000_1418800# a_755714_1418800# 3124.99833333 RPP
RXR122A a_787114_1424800# a_790714_1424800# 3124.99833333 RPP
RXR122B a_790714_1424800# a_1326428_1418800# 3124.99833333 RPP
RXR123A a_216400_1424800# a_220000_1424800# 3124.99833333 RPP
RXR123B a_220000_1424800# a_755714_1418800# 3124.99833333 RPP
RXR124A a_787114_1424800# a_790714_1430800# 3124.99833333 RPP
RXR124B a_790714_1430800# a_1326428_1430800# 3124.99833333 RPP
RXR125A a_216400_1424800# a_220000_1430800# 3124.99833333 RPP
RXR125B a_220000_1430800# a_755714_1430800# 3124.99833333 RPP
RXR126A a_787114_1436800# a_790714_1436800# 3124.99833333 RPP
RXR126B a_790714_1436800# a_1326428_1430800# 3124.99833333 RPP
RXR127A a_216400_1436800# a_220000_1436800# 3124.99833333 RPP
RXR127B a_220000_1436800# a_755714_1430800# 3124.99833333 RPP
RXR128A a_787114_1436800# a_790714_1442800# 3124.99833333 RPP
RXR128B a_790714_1442800# a_1326428_1442800# 3124.99833333 RPP
RXR129A a_216400_1436800# a_220000_1442800# 3124.99833333 RPP
RXR129B a_220000_1442800# a_755714_1442800# 3124.99833333 RPP
RXR130A a_787114_1448800# a_790714_1448800# 3124.99833333 RPP
RXR130B a_790714_1448800# a_1326428_1442800# 3124.99833333 RPP
RXR131A a_216400_1448800# a_220000_1448800# 3124.99833333 RPP
RXR131B a_220000_1448800# a_755714_1442800# 3124.99833333 RPP
RXR132A a_787114_1448800# a_790714_1454800# 3124.99833333 RPP
RXR132B a_790714_1454800# a_1326428_1454800# 3124.99833333 RPP
RXR133A a_216400_1448800# a_220000_1454800# 3124.99833333 RPP
RXR133B a_220000_1454800# a_755714_1454800# 3124.99833333 RPP
RXR134A a_787114_1460800# a_790714_1460800# 3124.99833333 RPP
RXR134B a_790714_1460800# a_1326428_1454800# 3124.99833333 RPP
RXR135A a_216400_1460800# a_220000_1460800# 3124.99833333 RPP
RXR135B a_220000_1460800# a_755714_1454800# 3124.99833333 RPP
RXR136A a_787114_1460800# a_790714_1466800# 3124.99833333 RPP
RXR136B a_790714_1466800# a_1326428_1466800# 3124.99833333 RPP
RXR137A a_216400_1460800# a_220000_1466800# 3124.99833333 RPP
RXR137B a_220000_1466800# a_755714_1466800# 3124.99833333 RPP
RXR138A a_787114_1472800# a_790714_1472800# 3124.99833333 RPP
RXR138B a_790714_1472800# a_1326428_1466800# 3124.99833333 RPP
RXR139A a_216400_1472800# a_220000_1472800# 3124.99833333 RPP
RXR139B a_220000_1472800# a_755714_1466800# 3124.99833333 RPP
RXR140A a_787114_1472800# a_790714_1478800# 3124.99833333 RPP
RXR140B a_790714_1478800# a_1326428_1478800# 3124.99833333 RPP
RXR141A a_216400_1472800# a_220000_1478800# 3124.99833333 RPP
RXR141B a_220000_1478800# a_755714_1478800# 3124.99833333 RPP
RXR142A a_787114_1484800# a_790714_1484800# 3124.99833333 RPP
RXR142B a_790714_1484800# a_1326428_1478800# 3124.99833333 RPP
RXR143A a_216400_1484800# a_220000_1484800# 3124.99833333 RPP
RXR143B a_220000_1484800# a_755714_1478800# 3124.99833333 RPP
RXR144A a_787114_1484800# a_790714_1490800# 3124.99833333 RPP
RXR144B a_790714_1490800# a_1326428_1490800# 3124.99833333 RPP
RXR145A a_216400_1484800# a_220000_1490800# 3124.99833333 RPP
RXR145B a_220000_1490800# a_755714_1490800# 3124.99833333 RPP
RXR146A a_787114_1496800# a_790714_1496800# 3124.99833333 RPP
RXR146B a_790714_1496800# a_1326428_1490800# 3124.99833333 RPP
RXR147A a_216400_1496800# a_220000_1496800# 3124.99833333 RPP
RXR147B a_220000_1496800# a_755714_1490800# 3124.99833333 RPP
RXR148A a_787114_1496800# a_790714_1502800# 3124.99833333 RPP
RXR148B a_790714_1502800# a_1326428_1502800# 3124.99833333 RPP
RXR149A a_216400_1496800# a_220000_1502800# 3124.99833333 RPP
RXR149B a_220000_1502800# a_755714_1502800# 3124.99833333 RPP
RXR150A a_787114_1508800# a_790714_1508800# 3124.99833333 RPP
RXR150B a_790714_1508800# a_1326428_1502800# 3124.99833333 RPP
RXR151A a_216400_1508800# a_220000_1508800# 3124.99833333 RPP
RXR151B a_220000_1508800# a_755714_1502800# 3124.99833333 RPP
RXR152A a_787114_1508800# a_790714_1514800# 3124.99833333 RPP
RXR152B a_790714_1514800# a_1326428_1514800# 3124.99833333 RPP
RXR153A a_216400_1508800# a_220000_1514800# 3124.99833333 RPP
RXR153B a_220000_1514800# a_755714_1514800# 3124.99833333 RPP
RXR154A a_787114_1520800# a_790714_1520800# 3124.99833333 RPP
RXR154B a_790714_1520800# a_1326428_1514800# 3124.99833333 RPP
RXR155A a_216400_1520800# a_220000_1520800# 3124.99833333 RPP
RXR155B a_220000_1520800# a_755714_1514800# 3124.99833333 RPP
RXR156A a_787114_1520800# a_790714_1526800# 3124.99833333 RPP
RXR156B a_790714_1526800# a_1326428_1526800# 3124.99833333 RPP
RXR157A a_216400_1520800# a_220000_1526800# 3124.99833333 RPP
RXR157B a_220000_1526800# a_755714_1526800# 3124.99833333 RPP
RXR158A a_787114_1532800# a_790714_1532800# 3124.99833333 RPP
RXR158B a_790714_1532800# a_1326428_1526800# 3124.99833333 RPP
RXR159A a_216400_1532800# a_220000_1532800# 3124.99833333 RPP
RXR159B a_220000_1532800# a_755714_1526800# 3124.99833333 RPP
RXR160A a_787114_1532800# a_790714_1538800# 3124.99833333 RPP
RXR160B a_790714_1538800# a_1326428_1538800# 3124.99833333 RPP
RXR161A a_216400_1532800# a_220000_1538800# 3124.99833333 RPP
RXR161B a_220000_1538800# a_755714_1538800# 3124.99833333 RPP
RXR162A a_787114_1544800# a_790714_1544800# 3124.99833333 RPP
RXR162B a_790714_1544800# a_1326428_1538800# 3124.99833333 RPP
RXR163A a_216400_1544800# a_220000_1544800# 3124.99833333 RPP
RXR163B a_220000_1544800# a_755714_1538800# 3124.99833333 RPP
RXR164A a_787114_1544800# a_790714_1550800# 3124.99833333 RPP
RXR164B a_790714_1550800# a_1326428_1550800# 3124.99833333 RPP
RXR165A a_216400_1544800# a_220000_1550800# 3124.99833333 RPP
RXR165B a_220000_1550800# a_755714_1550800# 3124.99833333 RPP
RXR166A a_787114_1556800# a_790714_1556800# 3124.99833333 RPP
RXR166B a_790714_1556800# a_1326428_1550800# 3124.99833333 RPP
RXR167A a_216400_1556800# a_220000_1556800# 3124.99833333 RPP
RXR167B a_220000_1556800# a_755714_1550800# 3124.99833333 RPP
RXR168A a_787114_1556800# a_790714_1562800# 3124.99833333 RPP
RXR168B a_790714_1562800# a_1326428_1562800# 3124.99833333 RPP
RXR169A a_216400_1556800# a_220000_1562800# 3124.99833333 RPP
RXR169B a_220000_1562800# a_755714_1562800# 3124.99833333 RPP
RXR170A a_787114_1568800# a_790714_1568800# 3124.99833333 RPP
RXR170B a_790714_1568800# a_1326428_1562800# 3124.99833333 RPP
RXR171A a_216400_1568800# a_220000_1568800# 3124.99833333 RPP
RXR171B a_220000_1568800# a_755714_1562800# 3124.99833333 RPP
RXR172A a_787114_1568800# a_790714_1574800# 3124.99833333 RPP
RXR172B a_790714_1574800# a_1326428_1574800# 3124.99833333 RPP
RXR173A a_216400_1568800# a_220000_1574800# 3124.99833333 RPP
RXR173B a_220000_1574800# a_755714_1574800# 3124.99833333 RPP
RXR174A a_787114_1580800# a_790714_1580800# 3124.99833333 RPP
RXR174B a_790714_1580800# a_1326428_1574800# 3124.99833333 RPP
RXR175A a_216400_1580800# a_220000_1580800# 3124.99833333 RPP
RXR175B a_220000_1580800# a_755714_1574800# 3124.99833333 RPP
RXR176A a_787114_1580800# a_790714_1586800# 3124.99833333 RPP
RXR176B a_790714_1586800# a_1326428_1586800# 3124.99833333 RPP
RXR177A a_216400_1580800# a_220000_1586800# 3124.99833333 RPP
RXR177B a_220000_1586800# a_755714_1586800# 3124.99833333 RPP
RXR178A a_787114_1592800# a_790714_1592800# 3124.99833333 RPP
RXR178B a_790714_1592800# a_1326428_1586800# 3124.99833333 RPP
RXR179A a_216400_1592800# a_220000_1592800# 3124.99833333 RPP
RXR179B a_220000_1592800# a_755714_1586800# 3124.99833333 RPP
RXR180A a_787114_1592800# a_790714_1598800# 3124.99833333 RPP
RXR180B a_790714_1598800# a_1326428_1598800# 3124.99833333 RPP
RXR181A a_216400_1592800# a_220000_1598800# 3124.99833333 RPP
RXR181B a_220000_1598800# a_755714_1598800# 3124.99833333 RPP
RXR182A a_787114_1604800# a_790714_1604800# 3124.99833333 RPP
RXR182B a_790714_1604800# a_1326428_1598800# 3124.99833333 RPP
RXR183A a_216400_1604800# a_220000_1604800# 3124.99833333 RPP
RXR183B a_220000_1604800# a_755714_1598800# 3124.99833333 RPP
RXR184A a_787114_1604800# a_790714_1610800# 3124.99833333 RPP
RXR184B a_790714_1610800# a_1326428_1610800# 3124.99833333 RPP
RXR185A a_216400_1604800# a_220000_1610800# 3124.99833333 RPP
RXR185B a_220000_1610800# a_755714_1610800# 3124.99833333 RPP
RXR186A a_787114_1616800# a_790714_1616800# 3124.99833333 RPP
RXR186B a_790714_1616800# a_1326428_1610800# 3124.99833333 RPP
RXR187A a_216400_1616800# a_220000_1616800# 3124.99833333 RPP
RXR187B a_220000_1616800# a_755714_1610800# 3124.99833333 RPP
RXR188A a_787114_1616800# a_790714_1622800# 3124.99833333 RPP
RXR188B a_790714_1622800# a_1326428_1622800# 3124.99833333 RPP
RXR189A a_216400_1616800# a_220000_1622800# 3124.99833333 RPP
RXR189B a_220000_1622800# a_755714_1622800# 3124.99833333 RPP
RXR190A a_787114_1628800# a_790714_1628800# 3124.99833333 RPP
RXR190B a_790714_1628800# a_1326428_1622800# 3124.99833333 RPP
RXR191A a_216400_1628800# a_220000_1628800# 3124.99833333 RPP
RXR191B a_220000_1628800# a_755714_1622800# 3124.99833333 RPP
RXR192A a_787114_1628800# a_790714_1634800# 3124.99833333 RPP
RXR192B a_790714_1634800# a_1326428_1634800# 3124.99833333 RPP
RXR193A a_216400_1628800# a_220000_1634800# 3124.99833333 RPP
RXR193B a_220000_1634800# a_755714_1634800# 3124.99833333 RPP
RXR194A a_787114_1640800# a_790714_1640800# 3124.99833333 RPP
RXR194B a_790714_1640800# a_1326428_1634800# 3124.99833333 RPP
RXR195A a_216400_1640800# a_220000_1640800# 3124.99833333 RPP
RXR195B a_220000_1640800# a_755714_1634800# 3124.99833333 RPP
RXR196A a_787114_1640800# a_790714_1646800# 3124.99833333 RPP
RXR196B a_790714_1646800# a_1326428_1646800# 3124.99833333 RPP
RXR197A a_216400_1640800# a_220000_1646800# 3124.99833333 RPP
RXR197B a_220000_1646800# a_755714_1646800# 3124.99833333 RPP
RXR198A a_787114_1652800# a_790714_1652800# 3124.99833333 RPP
RXR198B a_790714_1652800# a_1326428_1646800# 3124.99833333 RPP
RXR199A a_216400_1652800# a_220000_1652800# 3124.99833333 RPP
RXR199B a_220000_1652800# a_755714_1646800# 3124.99833333 RPP
RXR200A a_787114_1652800# a_790714_1658800# 3124.99833333 RPP
RXR200B a_790714_1658800# a_1326428_1658800# 3124.99833333 RPP
RXR201A a_216400_1652800# a_220000_1658800# 3124.99833333 RPP
RXR201B a_220000_1658800# a_755714_1658800# 3124.99833333 RPP
RXR202A a_787114_1664800# a_790714_1664800# 3124.99833333 RPP
RXR202B a_790714_1664800# a_1326428_1658800# 3124.99833333 RPP
RXR203A a_216400_1664800# a_220000_1664800# 3124.99833333 RPP
RXR203B a_220000_1664800# a_755714_1658800# 3124.99833333 RPP
RXR204A a_787114_1664800# a_790714_1670800# 3124.99833333 RPP
RXR204B a_790714_1670800# a_1326428_1670800# 3124.99833333 RPP
RXR205A a_216400_1664800# a_220000_1670800# 3124.99833333 RPP
RXR205B a_220000_1670800# a_755714_1670800# 3124.99833333 RPP
RXR206A a_787114_1676800# a_790714_1676800# 3124.99833333 RPP
RXR206B a_790714_1676800# a_1326428_1670800# 3124.99833333 RPP
RXR207A a_216400_1676800# a_220000_1676800# 3124.99833333 RPP
RXR207B a_220000_1676800# a_755714_1670800# 3124.99833333 RPP
RXR208A a_787114_1676800# a_790714_1682800# 3124.99833333 RPP
RXR208B a_790714_1682800# a_1326428_1682800# 3124.99833333 RPP
RXR209A a_216400_1676800# a_220000_1682800# 3124.99833333 RPP
RXR209B a_220000_1682800# a_755714_1682800# 3124.99833333 RPP
RXR210A a_787114_1688800# a_790714_1688800# 3124.99833333 RPP
RXR210B a_790714_1688800# a_1326428_1682800# 3124.99833333 RPP
RXR211A a_216400_1688800# a_220000_1688800# 3124.99833333 RPP
RXR211B a_220000_1688800# a_755714_1682800# 3124.99833333 RPP
RXR212A a_787114_1688800# a_790714_1694800# 3124.99833333 RPP
RXR212B a_790714_1694800# a_1326428_1694800# 3124.99833333 RPP
RXR213A a_216400_1688800# a_220000_1694800# 3124.99833333 RPP
RXR213B a_220000_1694800# a_755714_1694800# 3124.99833333 RPP
RXR214A a_787114_1700800# a_790714_1700800# 3124.99833333 RPP
RXR214B a_790714_1700800# a_1326428_1694800# 3124.99833333 RPP
RXR215A a_216400_1700800# a_220000_1700800# 3124.99833333 RPP
RXR215B a_220000_1700800# a_755714_1694800# 3124.99833333 RPP
RXR216A a_787114_1700800# a_790714_1706800# 3124.99833333 RPP
RXR216B a_790714_1706800# a_1326428_1706800# 3124.99833333 RPP
RXR217A a_216400_1700800# a_220000_1706800# 3124.99833333 RPP
RXR217B a_220000_1706800# a_755714_1706800# 3124.99833333 RPP
RXR218A a_787114_1712800# a_790714_1712800# 3124.99833333 RPP
RXR218B a_790714_1712800# a_1326428_1706800# 3124.99833333 RPP
RXR219A a_216400_1712800# a_220000_1712800# 3124.99833333 RPP
RXR219B a_220000_1712800# a_755714_1706800# 3124.99833333 RPP
RXR220A a_787114_1712800# a_790714_1718800# 3124.99833333 RPP
RXR220B a_790714_1718800# a_1326428_1718800# 3124.99833333 RPP
RXR221A a_216400_1712800# a_220000_1718800# 3124.99833333 RPP
RXR221B a_220000_1718800# a_755714_1718800# 3124.99833333 RPP
RXR222A a_787114_1724800# a_790714_1724800# 3124.99833333 RPP
RXR222B a_790714_1724800# a_1326428_1718800# 3124.99833333 RPP
RXR223A a_216400_1724800# a_220000_1724800# 3124.99833333 RPP
RXR223B a_220000_1724800# a_755714_1718800# 3124.99833333 RPP
RXR224A a_787114_1724800# a_790714_1730800# 3124.99833333 RPP
RXR224B a_790714_1730800# a_1326428_1730800# 3124.99833333 RPP
RXR225A a_216400_1724800# a_220000_1730800# 3124.99833333 RPP
RXR225B a_220000_1730800# a_755714_1730800# 3124.99833333 RPP
RXR226A a_787114_1736800# a_790714_1736800# 3124.99833333 RPP
RXR226B a_790714_1736800# a_1326428_1730800# 3124.99833333 RPP
RXR227A a_216400_1736800# a_220000_1736800# 3124.99833333 RPP
RXR227B a_220000_1736800# a_755714_1730800# 3124.99833333 RPP
RXR228A a_787114_1736800# a_790714_1742800# 3124.99833333 RPP
RXR228B a_790714_1742800# a_1326428_1742800# 3124.99833333 RPP
RXR229A a_216400_1736800# a_220000_1742800# 3124.99833333 RPP
RXR229B a_220000_1742800# a_755714_1742800# 3124.99833333 RPP
RXR230A a_787114_1748800# a_790714_1748800# 3124.99833333 RPP
RXR230B a_790714_1748800# a_1326428_1742800# 3124.99833333 RPP
RXR231A a_216400_1748800# a_220000_1748800# 3124.99833333 RPP
RXR231B a_220000_1748800# a_755714_1742800# 3124.99833333 RPP
RXR232A a_787114_1748800# a_790714_1754800# 3124.99833333 RPP
RXR232B a_790714_1754800# a_1326428_1754800# 3124.99833333 RPP
RXR233A a_216400_1748800# a_220000_1754800# 3124.99833333 RPP
RXR233B a_220000_1754800# a_755714_1754800# 3124.99833333 RPP
RXR234A a_787114_1760800# a_790714_1760800# 3124.99833333 RPP
RXR234B a_790714_1760800# a_1326428_1754800# 3124.99833333 RPP
RXR235A a_216400_1760800# a_220000_1760800# 3124.99833333 RPP
RXR235B a_220000_1760800# a_755714_1754800# 3124.99833333 RPP
RXR236A a_787114_1760800# a_790714_1766800# 3124.99833333 RPP
RXR236B a_790714_1766800# a_1326428_1766800# 3124.99833333 RPP
RXR237A a_216400_1760800# a_220000_1766800# 3124.99833333 RPP
RXR237B a_220000_1766800# a_755714_1766800# 3124.99833333 RPP
RXR238A a_787114_1772800# a_790714_1772800# 3124.99833333 RPP
RXR238B a_790714_1772800# a_1326428_1766800# 3124.99833333 RPP
RXR239A a_216400_1772800# a_220000_1772800# 3124.99833333 RPP
RXR239B a_220000_1772800# a_755714_1766800# 3124.99833333 RPP
RXR240A a_787114_1772800# a_790714_1778800# 3124.99833333 RPP
RXR240B a_790714_1778800# a_1326428_1778800# 3124.99833333 RPP
RXR241A a_216400_1772800# a_220000_1778800# 3124.99833333 RPP
RXR241B a_220000_1778800# a_755714_1778800# 3124.99833333 RPP
RXR242A a_787114_1784800# a_790714_1784800# 3124.99833333 RPP
RXR242B a_790714_1784800# a_1326428_1778800# 3124.99833333 RPP
RXR243A a_216400_1784800# a_220000_1784800# 3124.99833333 RPP
RXR243B a_220000_1784800# a_755714_1778800# 3124.99833333 RPP
RXR244A a_787114_1784800# a_790714_1790800# 3124.99833333 RPP
RXR244B a_790714_1790800# a_1326428_1790800# 3124.99833333 RPP
RXR245A a_216400_1784800# a_220000_1790800# 3124.99833333 RPP
RXR245B a_220000_1790800# a_755714_1790800# 3124.99833333 RPP
RXR246A a_787114_1796800# a_790714_1796800# 3124.99833333 RPP
RXR246B a_790714_1796800# a_1326428_1790800# 3124.99833333 RPP
RXR247A a_216400_1796800# a_220000_1796800# 3124.99833333 RPP
RXR247B a_220000_1796800# a_755714_1790800# 3124.99833333 RPP
RXR248A a_787114_1796800# a_790714_1802800# 3124.99833333 RPP
RXR248B a_790714_1802800# a_1326428_1802800# 3124.99833333 RPP
RXR249A a_216400_1796800# a_220000_1802800# 3124.99833333 RPP
RXR249B a_220000_1802800# a_755714_1802800# 3124.99833333 RPP
RXR250A a_787114_1808800# a_790714_1808800# 3124.99833333 RPP
RXR250B a_790714_1808800# a_1326428_1802800# 3124.99833333 RPP
RXR251A a_216400_1808800# a_220000_1808800# 3124.99833333 RPP
RXR251B a_220000_1808800# a_755714_1802800# 3124.99833333 RPP
RXR252A a_787114_1808800# a_790714_1814800# 3124.99833333 RPP
RXR252B a_790714_1814800# a_1326428_1814800# 3124.99833333 RPP
RXR253A a_216400_1808800# a_220000_1814800# 3124.99833333 RPP
RXR253B a_220000_1814800# a_755714_1814800# 3124.99833333 RPP
RXR254A a_787114_1820800# a_790714_1820800# 3124.99833333 RPP
RXR254B a_790714_1820800# a_1326428_1814800# 3124.99833333 RPP
RXR255A a_216400_1820800# a_220000_1820800# 3124.99833333 RPP
RXR255B a_220000_1820800# a_755714_1814800# 3124.99833333 RPP
RXR256A a_787114_1820800# a_790714_1826800# 3124.99833333 RPP
RXR256B a_790714_1826800# a_1326428_1826800# 3124.99833333 RPP
RXR257A a_216400_1820800# a_220000_1826800# 3124.99833333 RPP
RXR257B a_220000_1826800# a_755714_1826800# 3124.99833333 RPP
RXR258A a_787114_1832800# a_790714_1832800# 3124.99833333 RPP
RXR258B a_790714_1832800# a_1326428_1826800# 3124.99833333 RPP
RXR259A a_216400_1832800# a_220000_1832800# 3124.99833333 RPP
RXR259B a_220000_1832800# a_755714_1826800# 3124.99833333 RPP
RXR260A a_787114_1832800# a_790714_1838800# 3124.99833333 RPP
RXR260B a_790714_1838800# a_1326428_1838800# 3124.99833333 RPP
RXR261A a_216400_1832800# a_220000_1838800# 3124.99833333 RPP
RXR261B a_220000_1838800# a_755714_1838800# 3124.99833333 RPP
RXR262A a_787114_1844800# a_790714_1844800# 3124.99833333 RPP
RXR262B a_790714_1844800# a_1326428_1838800# 3124.99833333 RPP
RXR263A a_216400_1844800# a_220000_1844800# 3124.99833333 RPP
RXR263B a_220000_1844800# a_755714_1838800# 3124.99833333 RPP
RXR264A a_787114_1844800# a_790714_1850800# 3124.99833333 RPP
RXR264B a_790714_1850800# a_1326428_1850800# 3124.99833333 RPP
RXR265A a_216400_1844800# a_220000_1850800# 3124.99833333 RPP
RXR265B a_220000_1850800# a_755714_1850800# 3124.99833333 RPP
RXR266A a_787114_1856800# a_790714_1856800# 3124.99833333 RPP
RXR266B a_790714_1856800# a_1326428_1850800# 3124.99833333 RPP
RXR267A a_216400_1856800# a_220000_1856800# 3124.99833333 RPP
RXR267B a_220000_1856800# a_755714_1850800# 3124.99833333 RPP
RXR268A a_787114_1856800# a_790714_1862800# 3124.99833333 RPP
RXR268B a_790714_1862800# a_1326428_1862800# 3124.99833333 RPP
RXR269A a_216400_1856800# a_220000_1862800# 3124.99833333 RPP
RXR269B a_220000_1862800# a_755714_1862800# 3124.99833333 RPP
RXR270A a_787114_1868800# a_790714_1868800# 3124.99833333 RPP
RXR270B a_790714_1868800# a_1326428_1862800# 3124.99833333 RPP
RXR271A a_216400_1868800# a_220000_1868800# 3124.99833333 RPP
RXR271B a_220000_1868800# a_755714_1862800# 3124.99833333 RPP
RXR272A a_787114_1868800# a_790714_1874800# 3124.99833333 RPP
RXR272B a_790714_1874800# a_1326428_1874800# 3124.99833333 RPP
RXR273A a_216400_1868800# a_220000_1874800# 3124.99833333 RPP
RXR273B a_220000_1874800# a_755714_1874800# 3124.99833333 RPP
RXR274A a_787114_1880800# a_790714_1880800# 3124.99833333 RPP
RXR274B a_790714_1880800# a_1326428_1874800# 3124.99833333 RPP
RXR275A a_216400_1880800# a_220000_1880800# 3124.99833333 RPP
RXR275B a_220000_1880800# a_755714_1874800# 3124.99833333 RPP
RXR276A a_787114_1880800# a_790714_1886800# 3124.99833333 RPP
RXR276B a_790714_1886800# a_1326428_1886800# 3124.99833333 RPP
RXR277A a_216400_1880800# a_220000_1886800# 3124.99833333 RPP
RXR277B a_220000_1886800# a_755714_1886800# 3124.99833333 RPP
RXR278A a_787114_1892800# a_790714_1892800# 3124.99833333 RPP
RXR278B a_790714_1892800# a_1326428_1886800# 3124.99833333 RPP
RXR279A a_216400_1892800# a_220000_1892800# 3124.99833333 RPP
RXR279B a_220000_1892800# a_755714_1886800# 3124.99833333 RPP
RXR280A a_787114_1892800# a_790714_1898800# 3124.99833333 RPP
RXR280B a_790714_1898800# a_1326428_1898800# 3124.99833333 RPP
RXR281A a_216400_1892800# a_220000_1898800# 3124.99833333 RPP
RXR281B a_220000_1898800# a_755714_1898800# 3124.99833333 RPP
RXR282A a_787114_1904800# a_790714_1904800# 3124.99833333 RPP
RXR282B a_790714_1904800# a_1326428_1898800# 3124.99833333 RPP
RXR283A a_216400_1904800# a_220000_1904800# 3124.99833333 RPP
RXR283B a_220000_1904800# a_755714_1898800# 3124.99833333 RPP
RXR284A a_787114_1904800# a_790714_1910800# 3124.99833333 RPP
RXR284B a_790714_1910800# a_1326428_1910800# 3124.99833333 RPP
RXR285A a_216400_1904800# a_220000_1910800# 3124.99833333 RPP
RXR285B a_220000_1910800# a_755714_1910800# 3124.99833333 RPP
RXR286A a_787114_1916800# a_790714_1916800# 3124.99833333 RPP
RXR286B a_790714_1916800# a_1326428_1910800# 3124.99833333 RPP
RXR287A a_216400_1916800# a_220000_1916800# 3124.99833333 RPP
RXR287B a_220000_1916800# a_755714_1910800# 3124.99833333 RPP
RXR288A a_787114_1916800# a_790714_1922800# 3124.99833333 RPP
RXR288B a_790714_1922800# a_1326428_1922800# 3124.99833333 RPP
RXR289A a_216400_1916800# a_220000_1922800# 3124.99833333 RPP
RXR289B a_220000_1922800# a_755714_1922800# 3124.99833333 RPP
RXR290A a_787114_1928800# a_790714_1928800# 3124.99833333 RPP
RXR290B a_790714_1928800# a_1326428_1922800# 3124.99833333 RPP
RXR291A a_216400_1928800# a_220000_1928800# 3124.99833333 RPP
RXR291B a_220000_1928800# a_755714_1922800# 3124.99833333 RPP
RXR292A a_787114_1928800# a_790714_1934800# 3124.99833333 RPP
RXR292B a_790714_1934800# a_1326428_1934800# 3124.99833333 RPP
RXR293A a_216400_1928800# a_220000_1934800# 3124.99833333 RPP
RXR293B a_220000_1934800# a_755714_1934800# 3124.99833333 RPP
RXR294A a_787114_1940800# a_790714_1940800# 3124.99833333 RPP
RXR294B a_790714_1940800# a_1326428_1934800# 3124.99833333 RPP
RXR295A a_216400_1940800# a_220000_1940800# 3124.99833333 RPP
RXR295B a_220000_1940800# a_755714_1934800# 3124.99833333 RPP
RXR296A a_787114_1940800# a_790714_1946800# 3124.99833333 RPP
RXR296B a_790714_1946800# a_1326428_1946800# 3124.99833333 RPP
RXR297A a_216400_1940800# a_220000_1946800# 3124.99833333 RPP
RXR297B a_220000_1946800# a_755714_1946800# 3124.99833333 RPP
RXR298A a_787114_1952800# a_790714_1952800# 3124.99833333 RPP
RXR298B a_790714_1952800# a_1326428_1946800# 3124.99833333 RPP
RXR299A a_216400_1952800# a_220000_1952800# 3124.99833333 RPP
RXR299B a_220000_1952800# a_755714_1946800# 3124.99833333 RPP
RXR300A a_787114_1952800# a_790714_1958800# 3124.99833333 RPP
RXR300B a_790714_1958800# a_1326428_1958800# 3124.99833333 RPP
RXR301A a_216400_1952800# a_220000_1958800# 3124.99833333 RPP
RXR301B a_220000_1958800# a_755714_1958800# 3124.99833333 RPP
RXR302A a_787114_1964800# a_790714_1964800# 3124.99833333 RPP
RXR302B a_790714_1964800# a_1326428_1958800# 3124.99833333 RPP
RXR303A a_216400_1964800# a_220000_1964800# 3124.99833333 RPP
RXR303B a_220000_1964800# a_755714_1958800# 3124.99833333 RPP
RXR304A a_787114_1964800# a_790714_1970800# 3124.99833333 RPP
RXR304B a_790714_1970800# a_1326428_1970800# 3124.99833333 RPP
RXR305A a_216400_1964800# a_220000_1970800# 3124.99833333 RPP
RXR305B a_220000_1970800# a_755714_1970800# 3124.99833333 RPP
RXR306A a_787114_1976800# a_790714_1976800# 3124.99833333 RPP
RXR306B a_790714_1976800# a_1326428_1970800# 3124.99833333 RPP
RXR307A a_216400_1976800# a_220000_1976800# 3124.99833333 RPP
RXR307B a_220000_1976800# a_755714_1970800# 3124.99833333 RPP
RXR308A a_787114_1976800# a_790714_1982800# 3124.99833333 RPP
RXR308B a_790714_1982800# a_1326428_1982800# 3124.99833333 RPP
RXR309A a_216400_1976800# a_220000_1982800# 3124.99833333 RPP
RXR309B a_220000_1982800# a_755714_1982800# 3124.99833333 RPP
RXR310A a_787114_1988800# a_790714_1988800# 3124.99833333 RPP
RXR310B a_790714_1988800# a_1326428_1982800# 3124.99833333 RPP
RXR311A a_216400_1988800# a_220000_1988800# 3124.99833333 RPP
RXR311B a_220000_1988800# a_755714_1982800# 3124.99833333 RPP
RXR312A a_787114_1988800# a_790714_1994800# 3124.99833333 RPP
RXR312B a_790714_1994800# a_1326428_1994800# 3124.99833333 RPP
RXR313A a_216400_1988800# a_220000_1994800# 3124.99833333 RPP
RXR313B a_220000_1994800# a_755714_1994800# 3124.99833333 RPP
RXR314A a_787114_2000800# a_790714_2000800# 3124.99833333 RPP
RXR314B a_790714_2000800# a_1326428_1994800# 3124.99833333 RPP
RXR315A a_216400_2000800# a_220000_2000800# 3124.99833333 RPP
RXR315B a_220000_2000800# a_755714_1994800# 3124.99833333 RPP
RXR316A a_787114_2000800# a_790714_2006800# 3124.99833333 RPP
RXR316B a_790714_2006800# a_1326428_2006800# 3124.99833333 RPP
RXR317A a_216400_2000800# a_220000_2006800# 3124.99833333 RPP
RXR317B a_220000_2006800# a_755714_2006800# 3124.99833333 RPP
RXR318A a_216400_2012800# a_790714_2012800# 3124.99833333 RPP
RXR318B a_790714_2012800# a_1326428_2006800# 3124.99833333 RPP
RXR319A a_216400_2012800# a_220000_2012800# 3124.99833333 RPP
RXR319B a_220000_2012800# a_755714_2006800# 3124.99833333 RPP
.ends
