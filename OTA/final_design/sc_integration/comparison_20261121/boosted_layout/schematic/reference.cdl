* Independent source-model reference, external cascode references and integrated bias diode.
.subckt ota_boosted_layout INP INN OUTP OUTM VDD VSS IREF VCM NBOOST PBOOST
MSP VSS OUTP SP VDD P W=40.0u L=1.6u M=1
MSM VSS OUTM SM VDD P W=40.0u L=1.6u M=1
MSR VSS VCM SR VDD P W=40.0u L=1.6u M=1
MSIP SP CB VDD VDD P W=40.0u L=3.2u M=1
MSIM SM CB VDD VDD P W=40.0u L=3.2u M=1
MSIR SR CB VDD VDD P W=40.0u L=3.2u M=1
MCS CA SENSE CT VSS N W=10.0u L=2.4u M=1
MCR PC SR CT VSS N W=10.0u L=2.4u M=1
MCBI CB CB VDD VDD P W=20.0u L=3.2u M=1
MCBN CB IREF VSS VSS N W=11.428571u L=3.2u M=1
MCT CT IREF VSS VSS N W=11.428571u L=3.2u M=1
MCP1 CA CA VDD VDD P W=20.0u L=3.2u M=1
MCP2 PC CA VDD VDD P W=20.0u L=3.2u M=1
MCC VDD PC VDD VDD P W=20.0u L=10.0u M=4
MCM1 OUTP PC OUTP OUTP P W=20.0u L=10.0u M=8
MCM2 OUTM PC OUTM OUTM P W=20.0u L=10.0u M=8
MTAIL TAIL IREF VSS VSS N W=80.0u L=3.2u M=1
MN1 NX1 INP TAIL VSS N W=15.0u L=2.4u M=1
MN2 NX2 INN TAIL VSS N W=15.0u L=2.4u M=1
MNC1 OUTM GN1 NX1 VSS N W=30.0u L=2.4u M=1
MNC2 OUTP GN2 NX2 VSS N W=30.0u L=2.4u M=1
MPC1 OUTM GP1 PX1 VDD P W=60.0u L=2.4u M=1
MPC2 OUTP GP2 PX2 VDD P W=60.0u L=2.4u M=1
MP1 PX1 PC VDD VDD P W=40.0u L=3.2u M=1
MP2 PX2 PC VDD VDD P W=40.0u L=3.2u M=1
MAN1 GN1 NX1 AT1 VSS N W=10.0u L=1.6u M=1
MAR1 AM1 NBOOST AT1 VSS N W=10.0u L=1.6u M=1
MAT1 AT1 IREF VSS VSS N W=11.428571u L=3.2u M=1
MAP1 AM1 AM1 VDD VDD P W=20.0u L=1.6u M=1
MAO1 GN1 AM1 VDD VDD P W=20.0u L=1.6u M=1
MAN2 GN2 NX2 AT2 VSS N W=10.0u L=1.6u M=1
MAR2 AM2 NBOOST AT2 VSS N W=10.0u L=1.6u M=1
MAT2 AT2 IREF VSS VSS N W=11.428571u L=3.2u M=1
MAP2 AM2 AM2 VDD VDD P W=20.0u L=1.6u M=1
MAO2 GN2 AM2 VDD VDD P W=20.0u L=1.6u M=1
MPAB BPA BPA VDD VDD P W=20.0u L=3.2u M=1
MNAB BPA IREF VSS VSS N W=20.0u L=3.2u M=1
MPAN1 GP1 PX1 PAT1 VDD P W=20.0u L=1.6u M=1
MPAR1 PAM1 PBOOST PAT1 VDD P W=20.0u L=1.6u M=1
MPAT1 PAT1 BPA VDD VDD P W=11.428571u L=3.2u M=1
MPAP1 PAM1 PAM1 VSS VSS N W=10.0u L=1.6u M=1
MPAO1 GP1 PAM1 VSS VSS N W=10.0u L=1.6u M=1
MPAN2 GP2 PX2 PAT2 VDD P W=20.0u L=1.6u M=1
MPAR2 PAM2 PBOOST PAT2 VDD P W=20.0u L=1.6u M=1
MPAT2 PAT2 BPA VDD VDD P W=11.428571u L=3.2u M=1
MPAP2 PAM2 PAM2 VSS VSS N W=10.0u L=1.6u M=1
MPAO2 GP2 PAM2 VSS VSS N W=10.0u L=1.6u M=1
MREF IREF IREF VSS VSS N W=20u L=3.2u
RSP SP SENSE 1000000 RPP
RSM SM SENSE 1000000 RPP
.ends ota_boosted_layout
