* NGSPICE file created from ota_boosted_layout.ext - technology: SCL_CP8D

.subckt ota_boosted_layout INP INN OUTP OUTM VDD VSS IREF VCM NBOOST PBOOST
X0 a_216400_1100800# a_755714_1094800# RPP w=2.4u l=535.714u
X1 a_216400_1724800# a_755714_1730800# RPP w=2.4u l=535.714u
X2 a_787114_1544800# a_1326428_1550800# RPP w=2.4u l=535.714u
X3 a_787114_1436800# a_1326428_1442800# RPP w=2.4u l=535.714u
X4 a_216400_1616800# a_755714_1622800# RPP w=2.4u l=535.714u
X5 a_787114_1328800# a_1326428_1334800# RPP w=2.4u l=535.714u
X6 a_216400_1508800# a_755714_1514800# RPP w=2.4u l=535.714u
X7 a_787114_1964800# a_1326428_1958800# RPP w=2.4u l=535.714u
M1000 a_329600_989500# a_329600_989500# VDD VDD p w=20u l=3.2u
+  ad=90p pd=49u as=-1852.11p ps=1292.72u
X8 a_787114_1220800# a_1326428_1226800# RPP w=2.4u l=535.714u
X9 a_216400_1400800# a_755714_1406800# RPP w=2.4u l=535.714u
X10 a_787114_1856800# a_1326428_1850800# RPP w=2.4u l=535.714u
X11 a_787114_1112800# a_1326428_1118800# RPP w=2.4u l=535.714u
X12 a_787114_1748800# a_1326428_1742800# RPP w=2.4u l=535.714u
X13 a_216400_1928800# a_755714_1922800# RPP w=2.4u l=535.714u
M1001 a_218000_989500# IREF VSS VSS n w=11.429u l=3.2u
+  ad=51.4305p pd=31.858u as=925.722p ps=510.432u
X14 a_787114_1604800# a_1326428_1610800# RPP w=2.4u l=535.714u
X15 a_787114_1496800# a_1326428_1502800# RPP w=2.4u l=535.714u
X16 a_787114_1916800# a_1326428_1910800# RPP w=2.4u l=535.714u
M1002 a_213500_636600# IREF VSS VSS n w=11.429u l=3.2u
+  ad=141.431p pd=89.858u as=0p ps=0u
X17 a_787114_1808800# a_1326428_1802800# RPP w=2.4u l=535.714u
X18 a_216400_2012800# a_755714_2006800# RPP w=2.4u l=535.714u
X19 a_216400_1292800# a_755714_1298800# RPP w=2.4u l=535.714u
X20 a_216400_1160800# a_755714_1154800# RPP w=2.4u l=535.714u
X21 a_216400_1784800# a_755714_1790800# RPP w=2.4u l=535.714u
X22 a_216400_1676800# a_755714_1682800# RPP w=2.4u l=535.714u
X23 a_787114_1388800# a_1326428_1394800# RPP w=2.4u l=535.714u
X24 a_216400_1568800# a_755714_1574800# RPP w=2.4u l=535.714u
X25 a_787114_1280800# a_1326428_1286800# RPP w=2.4u l=535.714u
X26 a_216400_1460800# a_755714_1466800# RPP w=2.4u l=535.714u
X27 a_787114_2000800# a_1326428_1994800# RPP w=2.4u l=535.714u
M1003 OUTM a_218000_429300# OUTM OUTM p w=20u l=10u
+  ad=1710p pd=913u as=0p ps=0u
X28 a_787114_1172800# a_1326428_1178800# RPP w=2.4u l=535.714u
X29 a_216400_1352800# a_755714_1358800# RPP w=2.4u l=535.714u
X30 a_216400_1988800# a_755714_1982800# RPP w=2.4u l=535.714u
X31 a_216400_1220800# a_755714_1214800# RPP w=2.4u l=535.714u
X32 a_787114_1664800# a_1326428_1670800# RPP w=2.4u l=535.714u
X33 a_216400_1844800# a_755714_1850800# RPP w=2.4u l=535.714u
X34 a_216400_1112800# a_755714_1106800# RPP w=2.4u l=535.714u
X35 a_787114_1556800# a_1326428_1562800# RPP w=2.4u l=535.714u
X36 a_216400_1736800# a_755714_1742800# RPP w=2.4u l=535.714u
X37 a_216400_1628800# a_755714_1634800# RPP w=2.4u l=535.714u
X38 a_787114_1448800# a_1326428_1454800# RPP w=2.4u l=535.714u
X39 a_787114_1340800# a_1326428_1346800# RPP w=2.4u l=535.714u
X40 a_216400_1520800# a_755714_1526800# RPP w=2.4u l=535.714u
X41 a_787114_1976800# a_1326428_1970800# RPP w=2.4u l=535.714u
X42 a_787114_1232800# a_1326428_1238800# RPP w=2.4u l=535.714u
X43 a_216400_1412800# a_755714_1418800# RPP w=2.4u l=535.714u
X44 a_787114_1868800# a_1326428_1862800# RPP w=2.4u l=535.714u
X45 a_787114_1100800# a_1326428_1094800# RPP w=2.4u l=535.714u
X46 a_787114_1724800# a_1326428_1730800# RPP w=2.4u l=535.714u
X47 a_216400_1904800# a_755714_1910800# RPP w=2.4u l=535.714u
X48 a_787114_1616800# a_1326428_1622800# RPP w=2.4u l=535.714u
X49 a_216400_1796800# a_755714_1802800# RPP w=2.4u l=535.714u
X50 a_787114_1508800# a_1326428_1514800# RPP w=2.4u l=535.714u
M1004 OUTM a_219600_813800# a_217700_835900# VDD p w=60u l=2.4u
+  ad=0p pd=0u as=450p ps=218u
X51 a_787114_1400800# a_1326428_1406800# RPP w=2.4u l=535.714u
X52 a_787114_1928800# a_1326428_1922800# RPP w=2.4u l=535.714u
M1005 a_328000_718000# a_219600_718000# VDD VDD p w=20u l=1.6u
+  ad=90p pd=49u as=-0p ps=0u
M1006 a_253600_912900# IREF VSS VSS n w=20u l=3.2u
+  ad=90p pd=49u as=0p ps=0u
X53 a_216400_1280800# a_755714_1274800# RPP w=2.4u l=535.714u
M1007 a_213500_232000# a_218000_429300# VDD VDD p w=40u l=3.2u
+  ad=450p pd=218u as=-0p ps=0u
X54 a_216400_1172800# a_755714_1166800# RPP w=2.4u l=535.714u
M1008 OUTP a_218000_230500# a_213500_232000# VDD p w=60u l=2.4u
+  ad=1710p pd=913u as=0p ps=0u
M1009 a_294000_353400# a_218000_989500# VDD VDD p w=40u l=3.2u
+  ad=360p pd=178u as=-0p ps=0u
X55 a_216400_1064800# a_755714_1058800# RPP w=2.4u l=535.714u
X56 a_216400_1688800# a_755714_1694800# RPP w=2.4u l=535.714u
X57 a_216400_1580800# a_755714_1586800# RPP w=2.4u l=535.714u
X58 a_787114_1292800# a_1326428_1298800# RPP w=2.4u l=535.714u
X59 a_216400_1472800# a_755714_1478800# RPP w=2.4u l=535.714u
X60 a_216400_2012800# a_1326428_2006800# RPP w=2.4u l=535.714u
M1010 a_213500_914400# a_253600_912900# VDD VDD p w=11.429u l=3.2u
+  ad=231.431p pd=129.858u as=-0p ps=0u
X61 a_787114_1160800# a_1326428_1154800# RPP w=2.4u l=535.714u
X62 a_216400_1340800# a_755714_1334800# RPP w=2.4u l=535.714u
X63 a_787114_1784800# a_1326428_1790800# RPP w=2.4u l=535.714u
X64 a_216400_1964800# a_755714_1970800# RPP w=2.4u l=535.714u
X65 a_216400_1232800# a_755714_1226800# RPP w=2.4u l=535.714u
X66 a_787114_1676800# a_1326428_1682800# RPP w=2.4u l=535.714u
X67 a_216400_1856800# a_755714_1862800# RPP w=2.4u l=535.714u
X68 a_216400_1124800# a_755714_1118800# RPP w=2.4u l=535.714u
X69 a_787114_1568800# a_1326428_1574800# RPP w=2.4u l=535.714u
X70 a_216400_1748800# a_755714_1754800# RPP w=2.4u l=535.714u
X71 a_216400_1640800# a_755714_1646800# RPP w=2.4u l=535.714u
X72 a_787114_1460800# a_1326428_1466800# RPP w=2.4u l=535.714u
X73 a_787114_1352800# a_1326428_1358800# RPP w=2.4u l=535.714u
X74 a_216400_1532800# a_755714_1538800# RPP w=2.4u l=535.714u
X75 a_787114_1988800# a_1326428_1982800# RPP w=2.4u l=535.714u
X76 a_216400_1400800# a_755714_1394800# RPP w=2.4u l=535.714u
X77 a_787114_1220800# a_1326428_1214800# RPP w=2.4u l=535.714u
X78 a_787114_1844800# a_1326428_1850800# RPP w=2.4u l=535.714u
M1011 a_255200_636600# a_255200_636600# VDD VDD p w=20u l=1.6u
+  ad=90p pd=49u as=-0p ps=0u
X79 a_787114_1112800# a_1326428_1106800# RPP w=2.4u l=535.714u
X80 a_787114_1736800# a_1326428_1742800# RPP w=2.4u l=535.714u
X81 a_216400_1916800# a_755714_1922800# RPP w=2.4u l=535.714u
M1012 OUTP a_218000_429300# OUTP OUTP p w=20u l=10u
+  ad=0p pd=0u as=0p ps=0u
X82 a_787114_1628800# a_1326428_1634800# RPP w=2.4u l=535.714u
X83 a_216400_1808800# a_755714_1814800# RPP w=2.4u l=535.714u
X84 a_787114_1520800# a_1326428_1526800# RPP w=2.4u l=535.714u
X85 a_216400_1700800# a_755714_1706800# RPP w=2.4u l=535.714u
M1013 a_213500_813800# a_253600_912900# VDD VDD p w=11.429u l=3.2u
+  ad=231.431p pd=129.858u as=-0p ps=0u
X86 a_787114_1412800# a_1326428_1418800# RPP w=2.4u l=535.714u
X87 a_787114_1904800# a_1326428_1910800# RPP w=2.4u l=535.714u
M1014 a_217700_648700# INP a_221200_76200# VSS n w=15u l=2.4u
+  ad=202.5p pd=108u as=495p ps=247u
X88 a_787114_1796800# a_1326428_1802800# RPP w=2.4u l=535.714u
M1015 OUTP a_218000_429300# OUTP OUTP p w=20u l=10u
+  ad=0p pd=0u as=0p ps=0u
X89 a_216400_1292800# a_755714_1286800# RPP w=2.4u l=535.714u
X90 a_216400_1184800# a_755714_1178800# RPP w=2.4u l=535.714u
M1016 a_218000_429300# a_213500_353400# a_295600_991000# VSS n w=10u l=2.4u
+  ad=45p pd=29u as=141.431p ps=89.858u
X91 a_216400_1076800# a_755714_1070800# RPP w=2.4u l=535.714u
M1017 a_219600_914400# PBOOST a_213500_914400# VDD p w=20u l=1.6u
+  ad=90p pd=49u as=0p ps=0u
X92 a_216400_1592800# a_755714_1598800# RPP w=2.4u l=535.714u
X93 a_216400_1460800# a_755714_1454800# RPP w=2.4u l=535.714u
X94 a_787114_1280800# a_1326428_1274800# RPP w=2.4u l=535.714u
X95 a_787114_1172800# a_1326428_1166800# RPP w=2.4u l=535.714u
X96 a_216400_1352800# a_755714_1346800# RPP w=2.4u l=535.714u
X97 a_216400_1976800# a_755714_1982800# RPP w=2.4u l=535.714u
X98 a_787114_1064800# a_1326428_1058800# RPP w=2.4u l=535.714u
X99 a_216400_1244800# a_755714_1238800# RPP w=2.4u l=535.714u
X100 a_787114_1688800# a_1326428_1694800# RPP w=2.4u l=535.714u
X101 a_216400_1868800# a_755714_1874800# RPP w=2.4u l=535.714u
X102 a_216400_1136800# a_755714_1130800# RPP w=2.4u l=535.714u
X103 a_787114_1580800# a_1326428_1586800# RPP w=2.4u l=535.714u
X104 a_216400_1760800# a_755714_1766800# RPP w=2.4u l=535.714u
M1018 a_255200_813800# a_255200_813800# VSS VSS n w=10u l=1.6u
+  ad=45p pd=29u as=0p ps=0u
X105 a_787114_1472800# a_1326428_1478800# RPP w=2.4u l=535.714u
X106 a_216400_1652800# a_755714_1658800# RPP w=2.4u l=535.714u
X107 a_787114_1340800# a_1326428_1334800# RPP w=2.4u l=535.714u
X108 a_216400_1520800# a_755714_1514800# RPP w=2.4u l=535.714u
X109 a_787114_1964800# a_1326428_1970800# RPP w=2.4u l=535.714u
X110 a_787114_1232800# a_1326428_1226800# RPP w=2.4u l=535.714u
X111 a_216400_1412800# a_755714_1406800# RPP w=2.4u l=535.714u
X112 a_787114_1856800# a_1326428_1862800# RPP w=2.4u l=535.714u
X113 a_216400_1304800# a_755714_1298800# RPP w=2.4u l=535.714u
X114 a_216400_1928800# a_755714_1934800# RPP w=2.4u l=535.714u
X115 a_787114_1124800# a_1326428_1118800# RPP w=2.4u l=535.714u
X116 a_787114_1748800# a_1326428_1754800# RPP w=2.4u l=535.714u
X117 a_787114_1640800# a_1326428_1646800# RPP w=2.4u l=535.714u
X118 a_216400_1820800# a_755714_1826800# RPP w=2.4u l=535.714u
X119 a_787114_1532800# a_1326428_1538800# RPP w=2.4u l=535.714u
X120 a_216400_1712800# a_755714_1718800# RPP w=2.4u l=535.714u
M1019 IREF IREF VSS VSS n w=20u l=3.2u
+  ad=90p pd=49u as=0p ps=0u
X121 a_787114_1400800# a_1326428_1394800# RPP w=2.4u l=535.714u
X122 a_787114_1916800# a_1326428_1922800# RPP w=2.4u l=535.714u
X123 a_787114_1808800# a_1326428_1814800# RPP w=2.4u l=535.714u
M1020 a_219600_718000# a_219600_718000# VDD VDD p w=20u l=1.6u
+  ad=90p pd=49u as=-0p ps=0u
M1021 a_218000_989500# a_218000_989500# VDD VDD p w=20u l=3.2u
+  ad=90p pd=49u as=-0p ps=0u
X124 a_787114_1700800# a_1326428_1706800# RPP w=2.4u l=535.714u
M1022 OUTM a_219600_636600# a_217700_648700# VSS n w=30u l=2.4u
+  ad=207p pd=165u as=0p ps=0u
X125 a_216400_1196800# a_755714_1190800# RPP w=2.4u l=535.714u
X126 a_216400_1088800# a_755714_1082800# RPP w=2.4u l=535.714u
M1023 OUTP a_218000_429300# OUTP OUTP p w=20u l=10u
+  ad=0p pd=0u as=0p ps=0u
X127 a_216400_1580800# a_755714_1574800# RPP w=2.4u l=535.714u
X128 a_787114_1292800# a_1326428_1286800# RPP w=2.4u l=535.714u
X129 a_216400_1472800# a_755714_1466800# RPP w=2.4u l=535.714u
M1024 a_253600_912900# a_253600_912900# VDD VDD p w=20u l=3.2u
+  ad=90p pd=49u as=-0p ps=0u
X130 a_216400_1364800# a_755714_1358800# RPP w=2.4u l=535.714u
X131 a_787114_1184800# a_1326428_1178800# RPP w=2.4u l=535.714u
X132 a_216400_1988800# a_755714_1994800# RPP w=2.4u l=535.714u
X133 a_787114_1076800# a_1326428_1070800# RPP w=2.4u l=535.714u
X134 a_216400_1256800# a_755714_1250800# RPP w=2.4u l=535.714u
X135 a_216400_1880800# a_755714_1886800# RPP w=2.4u l=535.714u
M1025 VDD a_218000_429300# VDD VDD p w=20u l=10u
+  ad=-0p pd=0u as=-0p ps=0u
X136 a_216400_1148800# a_755714_1142800# RPP w=2.4u l=535.714u
X137 a_787114_1592800# a_1326428_1598800# RPP w=2.4u l=535.714u
X138 a_216400_1772800# a_755714_1778800# RPP w=2.4u l=535.714u
X139 a_787114_1460800# a_1326428_1454800# RPP w=2.4u l=535.714u
X140 a_216400_1640800# a_755714_1634800# RPP w=2.4u l=535.714u
M1026 VDD a_218000_429300# VDD VDD p w=20u l=10u
+  ad=-0p pd=0u as=-0p ps=0u
X141 a_787114_1352800# a_1326428_1346800# RPP w=2.4u l=535.714u
X142 a_216400_1532800# a_755714_1526800# RPP w=2.4u l=535.714u
X143 a_787114_1976800# a_1326428_1982800# RPP w=2.4u l=535.714u
M1027 a_328000_718000# a_294000_76200# a_213500_718000# VSS n w=10u l=1.6u
+  ad=45p pd=29u as=141.431p ps=89.858u
X144 a_787114_1244800# a_1326428_1238800# RPP w=2.4u l=535.714u
X145 a_216400_1424800# a_755714_1418800# RPP w=2.4u l=535.714u
X146 a_787114_1868800# a_1326428_1874800# RPP w=2.4u l=535.714u
M1028 VSS OUTP a_216400_1058800# VDD p w=40u l=1.6u
+  ad=729p pd=519u as=360p ps=178u
X147 a_216400_1316800# a_755714_1310800# RPP w=2.4u l=535.714u
X148 a_216400_1940800# a_755714_1946800# RPP w=2.4u l=535.714u
X149 a_787114_1136800# a_1326428_1130800# RPP w=2.4u l=535.714u
M1029 OUTM a_218000_429300# OUTM OUTM p w=20u l=10u
+  ad=0p pd=0u as=0p ps=0u
M1030 VDD a_218000_429300# VDD VDD p w=20u l=10u
+  ad=-0p pd=0u as=-0p ps=0u
X150 a_787114_1760800# a_1326428_1766800# RPP w=2.4u l=535.714u
X151 a_216400_1208800# a_755714_1202800# RPP w=2.4u l=535.714u
X152 a_787114_1652800# a_1326428_1658800# RPP w=2.4u l=535.714u
X153 a_216400_1832800# a_755714_1838800# RPP w=2.4u l=535.714u
X154 a_216400_1700800# a_755714_1694800# RPP w=2.4u l=535.714u
X155 a_787114_1520800# a_1326428_1514800# RPP w=2.4u l=535.714u
X156 a_787114_1412800# a_1326428_1406800# RPP w=2.4u l=535.714u
X157 a_787114_1304800# a_1326428_1298800# RPP w=2.4u l=535.714u
X158 a_787114_1928800# a_1326428_1934800# RPP w=2.4u l=535.714u
M1031 OUTM a_218000_429300# OUTM OUTM p w=20u l=10u
+  ad=0p pd=0u as=0p ps=0u
M1032 a_217700_835900# a_218000_429300# VDD VDD p w=40u l=3.2u
+  ad=0p pd=0u as=-0p ps=0u
M1033 a_219600_636600# a_255200_636600# VDD VDD p w=20u l=1.6u
+  ad=90p pd=49u as=-0p ps=0u
M1034 a_216400_1058800# a_218000_989500# VDD VDD p w=40u l=3.2u
+  ad=0p pd=0u as=-0p ps=0u
X159 a_787114_1820800# a_1326428_1826800# RPP w=2.4u l=535.714u
X160 a_787114_1712800# a_1326428_1718800# RPP w=2.4u l=535.714u
M1035 a_221200_76200# IREF VSS VSS n w=80u l=3.2u
+  ad=0p pd=0u as=0p ps=0u
M1036 OUTM a_218000_429300# OUTM OUTM p w=20u l=10u
+  ad=0p pd=0u as=0p ps=0u
X161 a_216400_1064800# a_755714_1070800# RPP w=2.4u l=535.714u
X162 a_216400_1592800# a_755714_1586800# RPP w=2.4u l=535.714u
X163 a_216400_1484800# a_755714_1478800# RPP w=2.4u l=535.714u
X164 a_216400_1376800# a_755714_1370800# RPP w=2.4u l=535.714u
X165 a_787114_1196800# a_1326428_1190800# RPP w=2.4u l=535.714u
M1037 OUTM a_218000_429300# OUTM OUTM p w=20u l=10u
+  ad=0p pd=0u as=0p ps=0u
X166 a_787114_1088800# a_1326428_1082800# RPP w=2.4u l=535.714u
X167 a_216400_1268800# a_755714_1262800# RPP w=2.4u l=535.714u
X168 a_216400_1892800# a_755714_1898800# RPP w=2.4u l=535.714u
X169 a_216400_1124800# a_755714_1130800# RPP w=2.4u l=535.714u
X170 a_216400_1760800# a_755714_1754800# RPP w=2.4u l=535.714u
X171 a_787114_1580800# a_1326428_1574800# RPP w=2.4u l=535.714u
X172 a_787114_1472800# a_1326428_1466800# RPP w=2.4u l=535.714u
X173 a_216400_1652800# a_755714_1646800# RPP w=2.4u l=535.714u
X174 a_787114_1364800# a_1326428_1358800# RPP w=2.4u l=535.714u
X175 a_216400_1544800# a_755714_1538800# RPP w=2.4u l=535.714u
X176 a_787114_1988800# a_1326428_1994800# RPP w=2.4u l=535.714u
X177 a_787114_1256800# a_1326428_1250800# RPP w=2.4u l=535.714u
X178 a_216400_1436800# a_755714_1430800# RPP w=2.4u l=535.714u
X179 a_787114_1880800# a_1326428_1886800# RPP w=2.4u l=535.714u
X180 a_787114_1148800# a_1326428_1142800# RPP w=2.4u l=535.714u
X181 a_216400_1328800# a_755714_1322800# RPP w=2.4u l=535.714u
X182 a_216400_1952800# a_755714_1958800# RPP w=2.4u l=535.714u
X183 a_787114_1772800# a_1326428_1778800# RPP w=2.4u l=535.714u
X184 a_787114_1640800# a_1326428_1634800# RPP w=2.4u l=535.714u
X185 a_216400_1820800# a_755714_1814800# RPP w=2.4u l=535.714u
X186 a_787114_1532800# a_1326428_1526800# RPP w=2.4u l=535.714u
X187 a_216400_1712800# a_755714_1706800# RPP w=2.4u l=535.714u
M1038 a_219600_813800# a_255200_813800# VSS VSS n w=10u l=1.6u
+  ad=45p pd=29u as=0p ps=0u
M1039 VSS VCM a_213500_353400# VDD p w=40u l=1.6u
+  ad=0p pd=0u as=360p ps=178u
X188 a_216400_1604800# a_755714_1598800# RPP w=2.4u l=535.714u
X189 a_787114_1424800# a_1326428_1418800# RPP w=2.4u l=535.714u
X190 a_787114_1316800# a_1326428_1310800# RPP w=2.4u l=535.714u
X191 a_787114_1940800# a_1326428_1946800# RPP w=2.4u l=535.714u
X192 a_787114_1208800# a_1326428_1202800# RPP w=2.4u l=535.714u
X193 a_787114_1832800# a_1326428_1838800# RPP w=2.4u l=535.714u
X194 a_787114_1700800# a_1326428_1694800# RPP w=2.4u l=535.714u
X195 a_216400_1184800# a_755714_1190800# RPP w=2.4u l=535.714u
X196 a_216400_1076800# a_755714_1082800# RPP w=2.4u l=535.714u
X197 a_216400_1496800# a_755714_1490800# RPP w=2.4u l=535.714u
M1040 a_218000_230500# a_219600_914400# VSS VSS n w=10u l=1.6u
+  ad=45p pd=29u as=0p ps=0u
M1041 a_213500_718000# IREF VSS VSS n w=11.429u l=3.2u
+  ad=0p pd=0u as=0p ps=0u
X198 a_216400_1388800# a_755714_1382800# RPP w=2.4u l=535.714u
X199 a_787114_1064800# a_1326428_1070800# RPP w=2.4u l=535.714u
X200 a_216400_1244800# a_755714_1250800# RPP w=2.4u l=535.714u
X201 a_216400_1880800# a_755714_1874800# RPP w=2.4u l=535.714u
X202 a_216400_1136800# a_755714_1142800# RPP w=2.4u l=535.714u
X203 a_216400_1772800# a_755714_1766800# RPP w=2.4u l=535.714u
X204 a_787114_1592800# a_1326428_1586800# RPP w=2.4u l=535.714u
M1042 a_218000_230500# a_213500_232000# a_213500_914400# VDD p w=20u l=1.6u
+  ad=90p pd=49u as=0p ps=0u
X205 a_216400_1664800# a_755714_1658800# RPP w=2.4u l=535.714u
X206 a_787114_1484800# a_1326428_1478800# RPP w=2.4u l=535.714u
X207 a_787114_1376800# a_1326428_1370800# RPP w=2.4u l=535.714u
X208 a_216400_1556800# a_755714_1550800# RPP w=2.4u l=535.714u
X209 a_787114_1268800# a_1326428_1262800# RPP w=2.4u l=535.714u
X210 a_216400_1448800# a_755714_1442800# RPP w=2.4u l=535.714u
X211 a_787114_1892800# a_1326428_1898800# RPP w=2.4u l=535.714u
X212 a_787114_1124800# a_1326428_1130800# RPP w=2.4u l=535.714u
X213 a_216400_1304800# a_755714_1310800# RPP w=2.4u l=535.714u
X214 a_787114_1760800# a_1326428_1754800# RPP w=2.4u l=535.714u
X215 a_216400_1940800# a_755714_1934800# RPP w=2.4u l=535.714u
X216 a_216400_1196800# a_755714_1202800# RPP w=2.4u l=535.714u
X217 a_787114_1652800# a_1326428_1646800# RPP w=2.4u l=535.714u
X218 a_216400_1832800# a_755714_1826800# RPP w=2.4u l=535.714u
M1043 a_294000_76200# INN a_221200_76200# VSS n w=15u l=2.4u
+  ad=202.5p pd=108u as=0p ps=0u
X219 a_787114_1544800# a_1326428_1538800# RPP w=2.4u l=535.714u
X220 a_216400_1724800# a_755714_1718800# RPP w=2.4u l=535.714u
X221 a_216400_1616800# a_755714_1610800# RPP w=2.4u l=535.714u
X222 a_787114_1436800# a_1326428_1430800# RPP w=2.4u l=535.714u
X223 a_787114_1328800# a_1326428_1322800# RPP w=2.4u l=535.714u
X224 a_216400_1508800# a_755714_1502800# RPP w=2.4u l=535.714u
X225 a_787114_1952800# a_1326428_1958800# RPP w=2.4u l=535.714u
M1044 a_255200_636600# NBOOST a_213500_636600# VSS n w=10u l=1.6u
+  ad=45p pd=29u as=0p ps=0u
X226 a_787114_1820800# a_1326428_1814800# RPP w=2.4u l=535.714u
X227 a_787114_1712800# a_1326428_1706800# RPP w=2.4u l=535.714u
X228 a_787114_1604800# a_1326428_1598800# RPP w=2.4u l=535.714u
M1045 a_218000_429300# a_329600_989500# VDD VDD p w=20u l=3.2u
+  ad=90p pd=49u as=-0p ps=0u
X229 a_216400_1088800# a_755714_1094800# RPP w=2.4u l=535.714u
M1046 a_219600_718000# NBOOST a_213500_718000# VSS n w=10u l=1.6u
+  ad=45p pd=29u as=0p ps=0u
M1047 a_295600_991000# IREF VSS VSS n w=11.429u l=3.2u
+  ad=0p pd=0u as=0p ps=0u
X230 a_787114_1184800# a_1326428_1190800# RPP w=2.4u l=535.714u
X231 a_216400_1364800# a_755714_1370800# RPP w=2.4u l=535.714u
X232 a_787114_1076800# a_1326428_1082800# RPP w=2.4u l=535.714u
X233 a_216400_1256800# a_755714_1262800# RPP w=2.4u l=535.714u
X234 a_216400_1892800# a_755714_1886800# RPP w=2.4u l=535.714u
X235 a_216400_2000800# a_755714_2006800# RPP w=2.4u l=535.714u
X236 a_216400_1148800# a_755714_1154800# RPP w=2.4u l=535.714u
X237 a_216400_1784800# a_755714_1778800# RPP w=2.4u l=535.714u
X238 a_216400_1676800# a_755714_1670800# RPP w=2.4u l=535.714u
M1048 a_213500_353400# a_218000_989500# VDD VDD p w=40u l=3.2u
+  ad=0p pd=0u as=-0p ps=0u
X239 a_787114_1496800# a_1326428_1490800# RPP w=2.4u l=535.714u
X240 a_787114_1388800# a_1326428_1382800# RPP w=2.4u l=535.714u
X241 a_216400_1568800# a_755714_1562800# RPP w=2.4u l=535.714u
M1049 OUTM a_218000_429300# OUTM OUTM p w=20u l=10u
+  ad=0p pd=0u as=0p ps=0u
X242 a_216400_1424800# a_755714_1430800# RPP w=2.4u l=535.714u
X243 a_787114_1244800# a_1326428_1250800# RPP w=2.4u l=535.714u
X244 a_787114_1880800# a_1326428_1874800# RPP w=2.4u l=535.714u
X245 a_787114_1136800# a_1326428_1142800# RPP w=2.4u l=535.714u
X246 a_216400_1316800# a_755714_1322800# RPP w=2.4u l=535.714u
X247 a_787114_1772800# a_1326428_1766800# RPP w=2.4u l=535.714u
X248 a_216400_1952800# a_755714_1946800# RPP w=2.4u l=535.714u
X249 a_216400_1208800# a_755714_1214800# RPP w=2.4u l=535.714u
X250 a_787114_1664800# a_1326428_1658800# RPP w=2.4u l=535.714u
X251 a_216400_1844800# a_755714_1838800# RPP w=2.4u l=535.714u
X252 a_216400_1100800# a_755714_1106800# RPP w=2.4u l=535.714u
M1050 VSS OUTM a_294000_353400# VDD p w=40u l=1.6u
+  ad=0p pd=0u as=0p ps=0u
X253 a_787114_1556800# a_1326428_1550800# RPP w=2.4u l=535.714u
X254 a_216400_1736800# a_755714_1730800# RPP w=2.4u l=535.714u
M1051 a_219600_636600# a_217700_648700# a_213500_636600# VSS n w=10u l=1.6u
+  ad=45p pd=29u as=0p ps=0u
M1052 OUTM a_218000_429300# OUTM OUTM p w=20u l=10u
+  ad=0p pd=0u as=0p ps=0u
X255 a_787114_1448800# a_1326428_1442800# RPP w=2.4u l=535.714u
X256 a_216400_1628800# a_755714_1622800# RPP w=2.4u l=535.714u
M1053 OUTP a_328000_718000# a_294000_76200# VSS n w=30u l=2.4u
+  ad=207p pd=165u as=0p ps=0u
M1054 OUTP a_218000_429300# OUTP OUTP p w=20u l=10u
+  ad=0p pd=0u as=0p ps=0u
X257 a_787114_1304800# a_1326428_1310800# RPP w=2.4u l=535.714u
X258 a_787114_1940800# a_1326428_1934800# RPP w=2.4u l=535.714u
X259 a_787114_1196800# a_1326428_1202800# RPP w=2.4u l=535.714u
X260 a_787114_1832800# a_1326428_1826800# RPP w=2.4u l=535.714u
M1055 OUTP a_218000_429300# OUTP OUTP p w=20u l=10u
+  ad=0p pd=0u as=0p ps=0u
X261 a_216400_1904800# a_755714_1898800# RPP w=2.4u l=535.714u
X262 a_787114_1724800# a_1326428_1718800# RPP w=2.4u l=535.714u
X263 a_787114_1616800# a_1326428_1610800# RPP w=2.4u l=535.714u
X264 a_787114_1508800# a_1326428_1502800# RPP w=2.4u l=535.714u
M1056 OUTP a_218000_429300# OUTP OUTP p w=20u l=10u
+  ad=0p pd=0u as=0p ps=0u
M1057 OUTP a_218000_429300# OUTP OUTP p w=20u l=10u
+  ad=0p pd=0u as=0p ps=0u
X265 a_216400_1484800# a_755714_1490800# RPP w=2.4u l=535.714u
M1058 a_219600_914400# a_219600_914400# VSS VSS n w=10u l=1.6u
+  ad=45p pd=29u as=0p ps=0u
M1059 OUTP a_218000_429300# OUTP OUTP p w=20u l=10u
+  ad=0p pd=0u as=0p ps=0u
X266 a_216400_1376800# a_755714_1382800# RPP w=2.4u l=535.714u
X267 a_787114_1088800# a_1326428_1094800# RPP w=2.4u l=535.714u
X268 a_216400_1268800# a_755714_1274800# RPP w=2.4u l=535.714u
X269 a_216400_1160800# a_755714_1166800# RPP w=2.4u l=535.714u
X270 a_216400_1796800# a_755714_1790800# RPP w=2.4u l=535.714u
X271 a_216400_1058800# a_755714_1058800# RPP w=2.4u l=535.714u
X272 a_216400_1688800# a_755714_1682800# RPP w=2.4u l=535.714u
X273 a_787114_1364800# a_1326428_1370800# RPP w=2.4u l=535.714u
X274 a_216400_1544800# a_755714_1550800# RPP w=2.4u l=535.714u
M1060 VDD a_218000_429300# VDD VDD p w=20u l=10u
+  ad=-0p pd=0u as=-0p ps=0u
M1061 a_329600_989500# a_216400_2012800# a_295600_991000# VSS n w=10u l=2.4u
+  ad=45p pd=29u as=0p ps=0u
X275 a_787114_1256800# a_1326428_1262800# RPP w=2.4u l=535.714u
X276 a_216400_1436800# a_755714_1442800# RPP w=2.4u l=535.714u
X277 a_787114_2000800# a_1326428_2006800# RPP w=2.4u l=535.714u
X278 a_787114_1892800# a_1326428_1886800# RPP w=2.4u l=535.714u
X279 a_216400_1328800# a_755714_1334800# RPP w=2.4u l=535.714u
X280 a_787114_1148800# a_1326428_1154800# RPP w=2.4u l=535.714u
X281 a_787114_1784800# a_1326428_1778800# RPP w=2.4u l=535.714u
X282 a_216400_1964800# a_755714_1958800# RPP w=2.4u l=535.714u
X283 a_216400_1220800# a_755714_1226800# RPP w=2.4u l=535.714u
X284 a_787114_1676800# a_1326428_1670800# RPP w=2.4u l=535.714u
X285 a_216400_1856800# a_755714_1850800# RPP w=2.4u l=535.714u
X286 a_216400_1112800# a_755714_1118800# RPP w=2.4u l=535.714u
X287 a_787114_1568800# a_1326428_1562800# RPP w=2.4u l=535.714u
X288 a_216400_1748800# a_755714_1742800# RPP w=2.4u l=535.714u
M1062 a_255200_813800# PBOOST a_213500_813800# VDD p w=20u l=1.6u
+  ad=90p pd=49u as=0p ps=0u
X289 a_787114_1424800# a_1326428_1430800# RPP w=2.4u l=535.714u
X290 a_216400_1604800# a_755714_1610800# RPP w=2.4u l=535.714u
X291 a_787114_1316800# a_1326428_1322800# RPP w=2.4u l=535.714u
X292 a_216400_1496800# a_755714_1502800# RPP w=2.4u l=535.714u
X293 a_787114_1952800# a_1326428_1946800# RPP w=2.4u l=535.714u
X294 a_787114_1208800# a_1326428_1214800# RPP w=2.4u l=535.714u
X295 a_787114_1844800# a_1326428_1838800# RPP w=2.4u l=535.714u
X296 a_216400_1916800# a_755714_1910800# RPP w=2.4u l=535.714u
X297 a_787114_1100800# a_1326428_1106800# RPP w=2.4u l=535.714u
X298 a_787114_1736800# a_1326428_1730800# RPP w=2.4u l=535.714u
X299 a_787114_1628800# a_1326428_1622800# RPP w=2.4u l=535.714u
X300 a_216400_1808800# a_755714_1802800# RPP w=2.4u l=535.714u
M1063 OUTM a_218000_429300# OUTM OUTM p w=20u l=10u
+  ad=0p pd=0u as=0p ps=0u
X301 a_787114_1904800# a_1326428_1898800# RPP w=2.4u l=535.714u
X302 a_216400_1388800# a_755714_1394800# RPP w=2.4u l=535.714u
X303 a_216400_2000800# a_755714_1994800# RPP w=2.4u l=535.714u
X304 a_216400_1280800# a_755714_1286800# RPP w=2.4u l=535.714u
X305 a_216400_1172800# a_755714_1178800# RPP w=2.4u l=535.714u
X306 a_787114_1484800# a_1326428_1490800# RPP w=2.4u l=535.714u
X307 a_216400_1664800# a_755714_1670800# RPP w=2.4u l=535.714u
X308 a_787114_1376800# a_1326428_1382800# RPP w=2.4u l=535.714u
X309 a_216400_1556800# a_755714_1562800# RPP w=2.4u l=535.714u
X310 a_787114_1268800# a_1326428_1274800# RPP w=2.4u l=535.714u
X311 a_216400_1448800# a_755714_1454800# RPP w=2.4u l=535.714u
X312 a_216400_1340800# a_755714_1346800# RPP w=2.4u l=535.714u
X313 a_216400_1976800# a_755714_1970800# RPP w=2.4u l=535.714u
X314 a_787114_1160800# a_1326428_1166800# RPP w=2.4u l=535.714u
X315 a_787114_1796800# a_1326428_1790800# RPP w=2.4u l=535.714u
M1064 a_219600_813800# a_217700_835900# a_213500_813800# VDD p w=20u l=1.6u
+  ad=90p pd=49u as=0p ps=0u
X316 a_294000_353400# a_1326428_1058800# RPP w=2.4u l=535.714u
X317 a_216400_1232800# a_755714_1238800# RPP w=2.4u l=535.714u
X318 a_787114_1688800# a_1326428_1682800# RPP w=2.4u l=535.714u
X319 a_216400_1868800# a_755714_1862800# RPP w=2.4u l=535.714u
C0 a_295600_991000# VDD 3.87fF
C1 a_219600_813800# a_255200_813800# 0.77fF
C2 a_213500_353400# a_217700_648700# 0.39fF
C3 a_217700_835900# a_328000_718000# 1.16fF
C4 a_213500_353400# IREF 0.77fF
C5 a_219600_813800# NBOOST 0.77fF
C6 a_218000_989500# OUTM 0.77fF
C7 a_219600_914400# VSS 2.32fF
C8 a_213500_232000# VCM 0.39fF
C9 a_294000_353400# OUTP 1.55fF
C10 a_218000_429300# PBOOST 1.16fF
C11 a_216400_1058800# a_217700_648700# 0.39fF
C12 a_294000_353400# a_328000_718000# 0.77fF
C13 a_253600_912900# a_218000_230500# 1.55fF
C14 a_213500_914400# a_213500_232000# 0.39fF
C15 a_221200_76200# OUTP 0.39fF
C16 a_216400_1058800# IREF 1.94fF
C17 a_213500_718000# VDD 4.26fF
C18 a_255200_636600# a_294000_76200# 0.39fF
C19 a_217700_648700# a_219600_636600# 1.55fF
C20 a_328000_718000# a_221200_76200# 1.16fF
C21 a_219600_636600# IREF 1.55fF
C22 INP INN 0.39fF
C23 a_216400_2012800# a_213500_914400# 0.77fF
C24 a_217700_648700# VSS 5.42fF
C25 a_329600_989500# a_295600_991000# 1.94fF
C26 a_218000_989500# a_218000_429300# 3.10fF
C27 a_216400_1058800# a_213500_353400# 0.39fF
C28 VDD VCM 11.67fF
C29 IREF VSS 12.00fF
C30 a_213500_914400# VDD 5.70fF
C31 a_217700_835900# a_217700_648700# 1.16fF
C32 a_213500_353400# a_219600_636600# 0.39fF
C33 a_294000_76200# INP 0.39fF
C34 a_217700_835900# IREF 2.32fF
C35 a_219600_718000# NBOOST 0.39fF
C36 a_213500_353400# VSS 4.26fF
C37 a_219600_813800# VCM 0.39fF
C38 a_218000_989500# OUTP 0.77fF
C39 a_219600_914400# PBOOST 0.39fF
C40 a_294000_353400# a_217700_648700# 0.39fF
C41 a_216400_1058800# a_219600_636600# 0.39fF
C42 a_218000_989500# a_328000_718000# 0.77fF
C43 a_213500_353400# a_217700_835900# 0.39fF
C44 a_253600_912900# a_213500_232000# 0.77fF
C45 a_213500_914400# a_219600_813800# 0.77fF
C46 a_294000_353400# IREF 1.94fF
C47 a_255200_636600# VDD 12.61fF
C48 a_213500_636600# a_294000_76200# 0.39fF
C49 a_217700_648700# a_221200_76200# 1.16fF
C50 a_218000_429300# NBOOST 0.77fF
C51 a_221200_76200# IREF 0.39fF
C52 a_216400_1058800# VSS 4.26fF
C53 a_216400_2012800# a_253600_912900# 0.39fF
C54 a_219600_636600# VSS 5.42fF
C55 a_216400_1058800# a_217700_835900# 0.77fF
C56 a_329600_989500# a_213500_914400# 0.77fF
C57 a_294000_353400# a_213500_353400# 0.39fF
C58 a_295600_991000# a_218000_429300# 1.16fF
C59 a_253600_912900# VDD 23.68fF
C60 a_218000_230500# a_294000_76200# 0.39fF
C61 a_217700_835900# a_219600_636600# 0.77fF
C62 a_219600_718000# a_213500_718000# 0.77fF
C63 VDD INP 0.39fF
C64 a_328000_718000# NBOOST 1.55fF
C65 a_294000_76200# INN 0.39fF
C66 a_217700_835900# VSS 7.36fF
C67 a_216400_1058800# a_294000_353400# 1.16fF
C68 a_213500_353400# PBOOST 1.16fF
C69 a_253600_912900# a_219600_813800# 1.16fF
C70 a_218000_230500# a_213500_232000# 1.16fF
C71 a_218000_989500# a_217700_648700# 0.39fF
C72 a_294000_353400# a_219600_636600# 0.39fF
C73 a_219600_813800# INP 0.39fF
C74 a_218000_989500# IREF 1.94fF
C75 a_213500_636600# VDD 1.55fF
C76 a_219600_636600# a_221200_76200# 1.16fF
C77 a_294000_353400# VSS 4.26fF
C78 a_218000_429300# VCM 0.77fF
C79 a_216400_2012800# a_218000_230500# 0.39fF
C80 a_221200_76200# VSS 2.32fF
C81 a_216400_1058800# PBOOST 0.77fF
C82 a_294000_353400# a_217700_835900# 0.77fF
C83 a_329600_989500# a_253600_912900# 0.39fF
C84 a_218000_989500# a_213500_353400# 1.16fF
C85 a_218000_429300# a_213500_914400# 0.77fF
C86 a_295600_991000# a_219600_914400# 1.55fF
C87 a_218000_230500# VDD 17.27fF
C88 a_213500_232000# a_294000_76200# 0.39fF
C89 a_217700_835900# a_221200_76200# 1.16fF
C90 a_213500_718000# a_328000_718000# 1.16fF
C91 a_217700_648700# NBOOST 0.77fF
C92 VSS PBOOST 4.26fF
C93 IREF NBOOST 1.55fF
C94 VDD INN 0.39fF
C95 OUTM INP 0.39fF
C96 a_213500_813800# VSS 1.55fF
C97 a_216400_1058800# a_218000_989500# 0.39fF
C98 a_328000_718000# VCM 0.39fF
C99 a_217700_835900# PBOOST 0.77fF
C100 a_253600_912900# a_219600_718000# 1.55fF
C101 a_218000_230500# a_219600_813800# 1.16fF
C102 a_217700_835900# a_213500_813800# 0.39fF
C103 a_218000_989500# a_219600_636600# 0.39fF
C104 a_295600_991000# IREF 1.16fF
C105 a_213500_353400# NBOOST 0.77fF
C106 a_294000_76200# VDD 3.48fF
C107 a_219600_813800# INN 0.39fF
C108 a_218000_989500# VSS 3.87fF
C109 a_294000_353400# PBOOST 0.77fF
C110 a_218000_429300# a_253600_912900# 0.77fF
C111 a_295600_991000# a_213500_353400# 0.39fF
C112 a_213500_914400# a_219600_914400# 0.77fF
C113 a_218000_989500# a_217700_835900# 0.39fF
C114 a_329600_989500# a_218000_230500# 0.39fF
C115 a_213500_232000# VDD 13.22fF
C116 a_216400_1058800# NBOOST 0.77fF
C117 a_219600_813800# a_294000_76200# 1.16fF
C118 a_328000_718000# a_255200_636600# 0.39fF
C119 a_213500_718000# a_217700_648700# 0.39fF
C120 a_213500_718000# IREF 1.55fF
C121 a_219600_636600# NBOOST 0.77fF
C122 a_218000_230500# OUTM 1.16fF
C123 a_255200_813800# VSS 1.55fF
C124 a_294000_353400# a_218000_989500# 0.39fF
C125 a_217700_648700# VCM 0.39fF
C126 a_216400_2012800# VDD 1.55fF
C127 OUTP INP 0.39fF
C128 VSS NBOOST 4.26fF
C129 OUTM INN 0.39fF
C130 a_213500_813800# PBOOST 0.39fF
C131 a_213500_232000# a_219600_813800# 1.16fF
C132 a_217700_835900# a_255200_813800# 0.39fF
C133 a_253600_912900# a_328000_718000# 0.39fF
C134 a_328000_718000# INP 0.39fF
C135 a_217700_835900# NBOOST 0.77fF
C136 a_295600_991000# VSS 4.26fF
C137 a_213500_353400# VCM 0.39fF
C138 a_294000_76200# OUTM 1.94fF
C139 a_218000_989500# PBOOST 0.77fF
C140 a_218000_429300# a_218000_230500# 1.55fF
C141 a_213500_914400# a_213500_353400# 0.77fF
C142 a_219600_914400# a_253600_912900# 0.39fF
C143 a_328000_718000# a_213500_636600# 0.39fF
C144 a_255200_636600# a_217700_648700# 0.39fF
C145 a_213500_718000# a_219600_636600# 0.77fF
C146 a_219600_813800# VDD 13.79fF
C147 a_294000_353400# NBOOST 0.77fF
C148 a_255200_636600# IREF 0.39fF
C149 a_213500_232000# OUTM 1.16fF
C150 a_216400_1058800# VCM 0.77fF
C151 a_216400_2012800# a_329600_989500# 0.77fF
C152 a_213500_718000# VSS 4.26fF
C153 a_219600_636600# VCM 0.39fF
C154 a_218000_230500# OUTP 1.55fF
C155 a_255200_813800# PBOOST 0.39fF
C156 a_329600_989500# VDD 16.62fF
C157 a_218000_429300# a_294000_76200# 0.39fF
C158 a_213500_813800# a_255200_813800# 1.16fF
C159 a_218000_230500# a_328000_718000# 0.77fF
C160 a_217700_648700# INP 0.39fF
C161 a_253600_912900# IREF 0.77fF
C162 VSS VCM 0.39fF
C163 IREF INP 0.39fF
C164 OUTP INN 0.39fF
C165 a_328000_718000# INN 0.39fF
C166 a_213500_914400# VSS 4.26fF
C167 VDD OUTM 9.70fF
C168 a_217700_835900# VCM 0.39fF
C169 a_295600_991000# PBOOST 0.39fF
C170 a_218000_429300# a_213500_232000# 1.16fF
C171 a_213500_914400# a_217700_835900# 0.39fF
C172 a_253600_912900# a_213500_353400# 0.77fF
C173 a_219600_914400# a_218000_230500# 0.39fF
C174 a_294000_76200# OUTP 1.55fF
C175 a_219600_718000# VDD 13.39fF
C176 a_255200_636600# a_219600_636600# 0.77fF
C177 a_328000_718000# a_294000_76200# 1.55fF
C178 a_217700_648700# a_213500_636600# 0.39fF
C179 a_218000_989500# NBOOST 0.77fF
C180 a_213500_636600# IREF 0.39fF
C181 a_219600_813800# OUTM 1.94fF
C182 a_294000_353400# VCM 0.77fF
C183 a_216400_2012800# a_218000_429300# 0.77fF
C184 a_255200_636600# VSS 1.94fF
C185 a_218000_989500# a_295600_991000# 1.55fF
C186 a_213500_232000# OUTP 1.55fF
C187 a_218000_230500# a_217700_648700# 0.39fF
C188 a_213500_232000# a_328000_718000# 0.77fF
C189 a_218000_429300# VDD 75.04fF
C190 a_219600_636600# INP 0.39fF
C191 a_218000_230500# IREF 1.55fF
C192 a_217700_648700# INN 0.39fF
C193 a_253600_912900# VSS 6.58fF
C194 VSS INP 0.39fF
C195 IREF INN 0.39fF
C196 a_213500_914400# PBOOST 1.16fF
C197 a_218000_429300# a_219600_813800# 0.39fF
C198 a_253600_912900# a_217700_835900# 0.77fF
C199 a_213500_914400# a_213500_813800# 1.16fF
C200 a_213500_353400# a_218000_230500# 1.16fF
C201 VDD OUTP 14.35fF
C202 a_217700_835900# INP 0.39fF
C203 a_328000_718000# VDD 6.93fF
C204 a_217700_648700# a_294000_76200# 1.55fF
C205 a_213500_636600# a_219600_636600# 0.77fF
C206 a_294000_76200# IREF 1.55fF
C207 a_218000_989500# VCM 0.39fF
C208 a_216400_2012800# a_219600_914400# 1.55fF
C209 a_213500_636600# VSS 1.94fF
C210 a_216400_1058800# a_218000_230500# 1.16fF
C211 a_329600_989500# a_218000_429300# 1.16fF
C212 a_219600_813800# OUTP 1.55fF
C213 a_219600_914400# VDD 1.90fF
C214 a_213500_232000# a_217700_648700# 0.39fF
C215 a_213500_353400# a_294000_76200# 0.39fF
C216 a_218000_230500# a_219600_636600# 0.39fF
C217 a_219600_813800# a_328000_718000# 1.16fF
C218 a_221200_76200# INP 0.39fF
C219 a_213500_232000# IREF 1.55fF
C220 a_213500_718000# NBOOST 1.16fF
C221 a_218000_429300# OUTM 96.60fF
C222 a_219600_636600# INN 0.39fF
C223 a_218000_230500# VSS 7.36fF
C224 a_253600_912900# PBOOST 1.55fF
C225 a_216400_1058800# a_294000_76200# 0.39fF
C226 a_213500_353400# a_213500_232000# 0.39fF
C227 a_213500_914400# a_255200_813800# 1.55fF
C228 a_218000_230500# a_217700_835900# 1.16fF
C229 a_253600_912900# a_213500_813800# 0.39fF
C230 a_216400_2012800# IREF 0.39fF
C231 VSS INN 0.39fF
C232 a_217700_648700# VDD 3.48fF
C233 a_219600_636600# a_294000_76200# 1.55fF
C234 VDD IREF 12.39fF
C235 OUTM OUTP 6.97fF
C236 a_217700_835900# INN 0.39fF
C237 a_328000_718000# OUTM 1.94fF
C238 a_216400_2012800# a_213500_353400# 0.39fF
C239 a_294000_76200# VSS 5.42fF
C240 a_294000_353400# a_218000_230500# 1.16fF
C241 a_329600_989500# a_219600_914400# 1.55fF
C242 a_216400_1058800# a_213500_232000# 1.16fF
C243 a_295600_991000# a_213500_914400# 0.77fF
C244 a_213500_353400# VDD 9.61fF
C245 a_219600_813800# a_217700_648700# 1.16fF
C246 a_217700_835900# a_294000_76200# 1.16fF
C247 a_213500_232000# a_219600_636600# 0.39fF
C248 a_219600_718000# a_328000_718000# 0.39fF
C249 a_219600_813800# IREF 1.55fF
C250 a_255200_636600# NBOOST 0.39fF
C251 a_216400_2012800# a_216400_1058800# 0.39fF
C252 a_221200_76200# INN 0.39fF
C253 a_213500_232000# VSS 4.65fF
C254 a_218000_429300# OUTP 96.98fF
C255 a_218000_230500# PBOOST 1.55fF
C256 a_218000_429300# a_328000_718000# 0.77fF
C257 a_213500_353400# a_219600_813800# 0.39fF
C258 a_218000_230500# a_213500_813800# 0.39fF
C259 a_217700_835900# a_213500_232000# 1.16fF
C260 a_253600_912900# a_255200_813800# 0.39fF
C261 a_216400_1058800# VDD 11.93fF
C262 a_294000_353400# a_294000_76200# 0.39fF
C263 a_329600_989500# IREF 1.16fF
C264 a_294000_76200# a_221200_76200# 1.16fF
C265 a_253600_912900# NBOOST 0.39fF
C266 a_219600_636600# VDD 4.22fF
C267 a_216400_2012800# VSS 2.71fF
C268 a_217700_648700# OUTM 1.94fF
C269 VDD VSS 22.74fF
C270 OUTM IREF 2.32fF
C271 a_216400_1058800# a_219600_813800# 0.39fF
C272 a_294000_353400# a_213500_232000# 1.16fF
C273 a_218000_989500# a_218000_230500# 0.77fF
C274 a_329600_989500# a_213500_353400# 0.39fF
C275 a_218000_429300# a_219600_914400# 0.39fF
C276 a_295600_991000# a_253600_912900# 0.39fF
C277 a_328000_718000# OUTP 1.55fF
C278 a_217700_835900# VDD 14.00fF
C279 a_219600_813800# a_219600_636600# 0.77fF
C280 a_213500_718000# a_255200_636600# 1.55fF
C281 a_219600_718000# IREF 0.77fF
C282 a_213500_636600# NBOOST 0.39fF
C283 a_213500_353400# OUTM 0.77fF
C284 a_216400_2012800# a_294000_353400# 0.39fF
C285 a_219600_813800# VSS 5.81fF
C286 a_213500_232000# PBOOST 0.77fF
C287 a_218000_429300# a_217700_648700# 0.39fF
C288 a_213500_232000# a_213500_813800# 0.39fF
C289 a_218000_230500# a_255200_813800# 0.39fF
C290 a_217700_835900# a_219600_813800# 1.55fF
C291 a_253600_912900# a_213500_718000# 0.77fF
C292 a_294000_353400# VDD 11.93fF
C293 a_218000_989500# a_294000_76200# 0.39fF
C294 a_218000_429300# IREF 2.71fF
C295 a_221200_76200# VDD 0.39fF
C296 a_218000_230500# NBOOST 0.77fF
C297 a_216400_1058800# OUTM 1.16fF
C298 a_329600_989500# VSS 4.26fF
C299 a_219600_636600# OUTM 1.94fF
C300 a_216400_2012800# PBOOST 0.39fF
C301 a_218000_429300# a_213500_353400# 2.71fF
C302 a_295600_991000# a_218000_230500# 0.39fF
C303 a_213500_914400# a_253600_912900# 1.16fF
C304 a_294000_353400# a_219600_813800# 0.39fF
C305 a_218000_989500# a_213500_232000# 0.39fF
C306 a_217700_648700# OUTP 1.55fF
C307 OUTP IREF 2.32fF
C308 OUTM VSS 2.32fF
C309 VDD PBOOST 13.81fF
C310 a_219600_813800# a_221200_76200# 1.16fF
C311 a_328000_718000# a_217700_648700# 1.55fF
C312 a_213500_718000# a_213500_636600# 1.16fF
C313 a_213500_813800# VDD 4.15fF
C314 a_328000_718000# IREF 2.71fF
C315 a_294000_76200# NBOOST 0.77fF
C316 a_217700_835900# OUTM 2.32fF
C317 a_216400_2012800# a_218000_989500# 0.39fF
C318 a_219600_718000# VSS 1.94fF
C319 a_216400_1058800# a_218000_429300# 3.87fF
C320 a_213500_353400# OUTP 0.77fF
C321 a_219600_813800# PBOOST 0.77fF
C322 a_218000_989500# VDD 38.87fF
C323 a_218000_429300# a_219600_636600# 0.39fF
C324 a_213500_232000# a_255200_813800# 0.39fF
C325 a_213500_813800# a_219600_813800# 0.77fF
C326 a_213500_353400# a_328000_718000# 0.77fF
C327 a_213500_232000# NBOOST 0.77fF
C328 a_294000_353400# OUTM 1.16fF
C329 a_218000_429300# VSS 8.13fF
C330 a_218000_230500# VCM 0.39fF
C331 a_221200_76200# OUTM 0.77fF
C332 a_216400_1058800# OUTP 1.55fF
C333 a_329600_989500# PBOOST 0.39fF
C334 a_218000_429300# a_217700_835900# 0.77fF
C335 a_219600_914400# a_213500_353400# 0.39fF
C336 a_213500_914400# a_218000_230500# 1.16fF
C337 a_218000_989500# a_219600_813800# 0.39fF
C338 a_216400_1058800# a_328000_718000# 0.77fF
C339 a_219600_636600# OUTP 1.55fF
C340 a_255200_813800# VDD 2.67fF
C341 a_328000_718000# a_219600_636600# 1.55fF
C342 a_255200_636600# a_213500_636600# 1.16fF
C343 a_213500_718000# a_294000_76200# 0.39fF
C344 a_217700_648700# IREF 1.55fF
C345 VDD NBOOST 4.26fF
C346 OUTP VSS 2.32fF
C347 a_216400_2012800# a_295600_991000# 0.39fF
C348 a_328000_718000# VSS 7.74fF
C349 a_218000_989500# a_329600_989500# 1.55fF
C350 a_294000_353400# a_218000_429300# 3.87fF
C351 a_294000_76200# VCM 0.39fF
C352 a_217700_835900# OUTP 2.32fF
C353 INN 0 4.10fF
C354 INP 0 3.44fF
C355 VCM 0 52.56fF
C356 NBOOST 0 118.69fF
C357 PBOOST 0 117.12fF
C358 VSS 0 2.06fF
C359 IREF 0 456.30fF
C360 OUTP 0 6.02fF
C361 OUTM 0 4.70fF
C362 VDD 0 3.38fF
C363 a_221200_76200# 0 62.82fF
C364 a_294000_76200# 0 182.02fF
C365 a_219600_636600# 0 181.34fF
C366 a_213500_636600# 0 44.48fF
C367 a_217700_648700# 0 185.90fF
C368 a_255200_636600# 0 46.13fF
C369 a_328000_718000# 0 226.42fF
C370 a_213500_718000# 0 82.60fF
C371 a_219600_718000# 0 45.83fF
C372 a_255200_813800# 0 50.45fF
C373 a_219600_813800# 0 200.95fF
C374 a_213500_813800# 0 39.21fF
C375 a_213500_232000# 0 171.38fF
C376 a_217700_835900# 0 230.62fF
C377 a_218000_230500# 0 231.05fF
C378 a_213500_353400# 0 166.35fF
C379 a_253600_912900# 0 136.25fF
C380 a_219600_914400# 0 55.90fF
C381 a_213500_914400# 0 78.61fF
C382 a_218000_429300# 0 477.04fF
C383 a_295600_991000# 0 64.93fF
C384 a_329600_989500# 0 76.91fF
C385 a_218000_989500# 0 185.06fF
C386 a_790714_1058800# 0 171.00fF $ **FLOATING
C387 a_294000_353400# 0 283.46fF
C388 a_220000_1058800# 0 171.00fF $ **FLOATING
C389 a_216400_1058800# 0 218.06fF
C390 a_1326428_1058800# 0 3.06fF
C391 a_790714_1064800# 0 171.00fF $ **FLOATING
C392 a_755714_1058800# 0 3.06fF
C393 a_220000_1064800# 0 171.00fF $ **FLOATING
C394 a_790714_1070800# 0 171.00fF $ **FLOATING
C395 a_787114_1064800# 0 3.06fF
C396 a_220000_1070800# 0 171.00fF $ **FLOATING
C397 a_216400_1064800# 0 3.06fF
C398 a_1326428_1070800# 0 3.06fF
C399 a_790714_1076800# 0 171.00fF $ **FLOATING
C400 a_755714_1070800# 0 3.06fF
C401 a_220000_1076800# 0 171.00fF $ **FLOATING
C402 a_790714_1082800# 0 171.00fF $ **FLOATING
C403 a_787114_1076800# 0 3.06fF
C404 a_220000_1082800# 0 171.00fF $ **FLOATING
C405 a_216400_1076800# 0 3.06fF
C406 a_1326428_1082800# 0 3.06fF
C407 a_790714_1088800# 0 171.00fF $ **FLOATING
C408 a_755714_1082800# 0 3.06fF
C409 a_220000_1088800# 0 171.00fF $ **FLOATING
C410 a_790714_1094800# 0 171.00fF $ **FLOATING
C411 a_787114_1088800# 0 3.06fF
C412 a_220000_1094800# 0 171.00fF $ **FLOATING
C413 a_216400_1088800# 0 3.06fF
C414 a_1326428_1094800# 0 3.06fF
C415 a_790714_1100800# 0 171.00fF $ **FLOATING
C416 a_755714_1094800# 0 3.06fF
C417 a_220000_1100800# 0 171.00fF $ **FLOATING
C418 a_790714_1106800# 0 171.00fF $ **FLOATING
C419 a_787114_1100800# 0 3.06fF
C420 a_220000_1106800# 0 171.00fF $ **FLOATING
C421 a_216400_1100800# 0 3.06fF
C422 a_1326428_1106800# 0 3.06fF
C423 a_790714_1112800# 0 171.00fF $ **FLOATING
C424 a_755714_1106800# 0 3.06fF
C425 a_220000_1112800# 0 171.00fF $ **FLOATING
C426 a_790714_1118800# 0 171.00fF $ **FLOATING
C427 a_787114_1112800# 0 3.06fF
C428 a_220000_1118800# 0 171.00fF $ **FLOATING
C429 a_216400_1112800# 0 3.06fF
C430 a_1326428_1118800# 0 3.06fF
C431 a_790714_1124800# 0 171.00fF $ **FLOATING
C432 a_755714_1118800# 0 3.06fF
C433 a_220000_1124800# 0 171.00fF $ **FLOATING
C434 a_790714_1130800# 0 171.00fF $ **FLOATING
C435 a_787114_1124800# 0 3.06fF
C436 a_220000_1130800# 0 171.00fF $ **FLOATING
C437 a_216400_1124800# 0 3.06fF
C438 a_1326428_1130800# 0 3.06fF
C439 a_790714_1136800# 0 171.00fF $ **FLOATING
C440 a_755714_1130800# 0 3.06fF
C441 a_220000_1136800# 0 171.00fF $ **FLOATING
C442 a_790714_1142800# 0 171.00fF $ **FLOATING
C443 a_787114_1136800# 0 3.06fF
C444 a_220000_1142800# 0 171.00fF $ **FLOATING
C445 a_216400_1136800# 0 3.06fF
C446 a_1326428_1142800# 0 3.06fF
C447 a_790714_1148800# 0 171.00fF $ **FLOATING
C448 a_755714_1142800# 0 3.06fF
C449 a_220000_1148800# 0 171.00fF $ **FLOATING
C450 a_790714_1154800# 0 171.00fF $ **FLOATING
C451 a_787114_1148800# 0 3.06fF
C452 a_220000_1154800# 0 171.00fF $ **FLOATING
C453 a_216400_1148800# 0 3.06fF
C454 a_1326428_1154800# 0 3.06fF
C455 a_790714_1160800# 0 171.00fF $ **FLOATING
C456 a_755714_1154800# 0 3.06fF
C457 a_220000_1160800# 0 171.00fF $ **FLOATING
C458 a_790714_1166800# 0 171.00fF $ **FLOATING
C459 a_787114_1160800# 0 3.06fF
C460 a_220000_1166800# 0 171.00fF $ **FLOATING
C461 a_216400_1160800# 0 3.06fF
C462 a_1326428_1166800# 0 3.06fF
C463 a_790714_1172800# 0 171.00fF $ **FLOATING
C464 a_755714_1166800# 0 3.06fF
C465 a_220000_1172800# 0 171.00fF $ **FLOATING
C466 a_790714_1178800# 0 171.00fF $ **FLOATING
C467 a_787114_1172800# 0 3.06fF
C468 a_220000_1178800# 0 171.00fF $ **FLOATING
C469 a_216400_1172800# 0 3.06fF
C470 a_1326428_1178800# 0 3.06fF
C471 a_790714_1184800# 0 171.00fF $ **FLOATING
C472 a_755714_1178800# 0 3.06fF
C473 a_220000_1184800# 0 171.00fF $ **FLOATING
C474 a_790714_1190800# 0 171.00fF $ **FLOATING
C475 a_787114_1184800# 0 3.06fF
C476 a_220000_1190800# 0 171.00fF $ **FLOATING
C477 a_216400_1184800# 0 3.06fF
C478 a_1326428_1190800# 0 3.06fF
C479 a_790714_1196800# 0 171.00fF $ **FLOATING
C480 a_755714_1190800# 0 3.06fF
C481 a_220000_1196800# 0 171.00fF $ **FLOATING
C482 a_790714_1202800# 0 171.00fF $ **FLOATING
C483 a_787114_1196800# 0 3.06fF
C484 a_220000_1202800# 0 171.00fF $ **FLOATING
C485 a_216400_1196800# 0 3.06fF
C486 a_1326428_1202800# 0 3.06fF
C487 a_790714_1208800# 0 171.00fF $ **FLOATING
C488 a_755714_1202800# 0 3.06fF
C489 a_220000_1208800# 0 171.00fF $ **FLOATING
C490 a_790714_1214800# 0 171.00fF $ **FLOATING
C491 a_787114_1208800# 0 3.06fF
C492 a_220000_1214800# 0 171.00fF $ **FLOATING
C493 a_216400_1208800# 0 3.06fF
C494 a_1326428_1214800# 0 3.06fF
C495 a_790714_1220800# 0 171.00fF $ **FLOATING
C496 a_755714_1214800# 0 3.06fF
C497 a_220000_1220800# 0 171.00fF $ **FLOATING
C498 a_790714_1226800# 0 171.00fF $ **FLOATING
C499 a_787114_1220800# 0 3.06fF
C500 a_220000_1226800# 0 171.00fF $ **FLOATING
C501 a_216400_1220800# 0 3.06fF
C502 a_1326428_1226800# 0 3.06fF
C503 a_790714_1232800# 0 171.00fF $ **FLOATING
C504 a_755714_1226800# 0 3.06fF
C505 a_220000_1232800# 0 171.00fF $ **FLOATING
C506 a_790714_1238800# 0 171.00fF $ **FLOATING
C507 a_787114_1232800# 0 3.06fF
C508 a_220000_1238800# 0 171.00fF $ **FLOATING
C509 a_216400_1232800# 0 3.06fF
C510 a_1326428_1238800# 0 3.06fF
C511 a_790714_1244800# 0 171.00fF $ **FLOATING
C512 a_755714_1238800# 0 3.06fF
C513 a_220000_1244800# 0 171.00fF $ **FLOATING
C514 a_790714_1250800# 0 171.00fF $ **FLOATING
C515 a_787114_1244800# 0 3.06fF
C516 a_220000_1250800# 0 171.00fF $ **FLOATING
C517 a_216400_1244800# 0 3.06fF
C518 a_1326428_1250800# 0 3.06fF
C519 a_790714_1256800# 0 171.00fF $ **FLOATING
C520 a_755714_1250800# 0 3.06fF
C521 a_220000_1256800# 0 171.00fF $ **FLOATING
C522 a_790714_1262800# 0 171.00fF $ **FLOATING
C523 a_787114_1256800# 0 3.06fF
C524 a_220000_1262800# 0 171.00fF $ **FLOATING
C525 a_216400_1256800# 0 3.06fF
C526 a_1326428_1262800# 0 3.06fF
C527 a_790714_1268800# 0 171.00fF $ **FLOATING
C528 a_755714_1262800# 0 3.06fF
C529 a_220000_1268800# 0 171.00fF $ **FLOATING
C530 a_790714_1274800# 0 171.00fF $ **FLOATING
C531 a_787114_1268800# 0 3.06fF
C532 a_220000_1274800# 0 171.00fF $ **FLOATING
C533 a_216400_1268800# 0 3.06fF
C534 a_1326428_1274800# 0 3.06fF
C535 a_790714_1280800# 0 171.00fF $ **FLOATING
C536 a_755714_1274800# 0 3.06fF
C537 a_220000_1280800# 0 171.00fF $ **FLOATING
C538 a_790714_1286800# 0 171.00fF $ **FLOATING
C539 a_787114_1280800# 0 3.06fF
C540 a_220000_1286800# 0 171.00fF $ **FLOATING
C541 a_216400_1280800# 0 3.06fF
C542 a_1326428_1286800# 0 3.06fF
C543 a_790714_1292800# 0 171.00fF $ **FLOATING
C544 a_755714_1286800# 0 3.06fF
C545 a_220000_1292800# 0 171.00fF $ **FLOATING
C546 a_790714_1298800# 0 171.00fF $ **FLOATING
C547 a_787114_1292800# 0 3.06fF
C548 a_220000_1298800# 0 171.00fF $ **FLOATING
C549 a_216400_1292800# 0 3.06fF
C550 a_1326428_1298800# 0 3.06fF
C551 a_790714_1304800# 0 171.00fF $ **FLOATING
C552 a_755714_1298800# 0 3.06fF
C553 a_220000_1304800# 0 171.00fF $ **FLOATING
C554 a_790714_1310800# 0 171.00fF $ **FLOATING
C555 a_787114_1304800# 0 3.06fF
C556 a_220000_1310800# 0 171.00fF $ **FLOATING
C557 a_216400_1304800# 0 3.06fF
C558 a_1326428_1310800# 0 3.06fF
C559 a_790714_1316800# 0 171.00fF $ **FLOATING
C560 a_755714_1310800# 0 3.06fF
C561 a_220000_1316800# 0 171.00fF $ **FLOATING
C562 a_790714_1322800# 0 171.00fF $ **FLOATING
C563 a_787114_1316800# 0 3.06fF
C564 a_220000_1322800# 0 171.00fF $ **FLOATING
C565 a_216400_1316800# 0 3.06fF
C566 a_1326428_1322800# 0 3.06fF
C567 a_790714_1328800# 0 171.00fF $ **FLOATING
C568 a_755714_1322800# 0 3.06fF
C569 a_220000_1328800# 0 171.00fF $ **FLOATING
C570 a_790714_1334800# 0 171.00fF $ **FLOATING
C571 a_787114_1328800# 0 3.06fF
C572 a_220000_1334800# 0 171.00fF $ **FLOATING
C573 a_216400_1328800# 0 3.06fF
C574 a_1326428_1334800# 0 3.06fF
C575 a_790714_1340800# 0 171.00fF $ **FLOATING
C576 a_755714_1334800# 0 3.06fF
C577 a_220000_1340800# 0 171.00fF $ **FLOATING
C578 a_790714_1346800# 0 171.00fF $ **FLOATING
C579 a_787114_1340800# 0 3.06fF
C580 a_220000_1346800# 0 171.00fF $ **FLOATING
C581 a_216400_1340800# 0 3.06fF
C582 a_1326428_1346800# 0 3.06fF
C583 a_790714_1352800# 0 171.00fF $ **FLOATING
C584 a_755714_1346800# 0 3.06fF
C585 a_220000_1352800# 0 171.00fF $ **FLOATING
C586 a_790714_1358800# 0 171.00fF $ **FLOATING
C587 a_787114_1352800# 0 3.06fF
C588 a_220000_1358800# 0 171.00fF $ **FLOATING
C589 a_216400_1352800# 0 3.06fF
C590 a_1326428_1358800# 0 3.06fF
C591 a_790714_1364800# 0 171.00fF $ **FLOATING
C592 a_755714_1358800# 0 3.06fF
C593 a_220000_1364800# 0 171.00fF $ **FLOATING
C594 a_790714_1370800# 0 171.00fF $ **FLOATING
C595 a_787114_1364800# 0 3.06fF
C596 a_220000_1370800# 0 171.00fF $ **FLOATING
C597 a_216400_1364800# 0 3.06fF
C598 a_1326428_1370800# 0 3.06fF
C599 a_790714_1376800# 0 171.00fF $ **FLOATING
C600 a_755714_1370800# 0 3.06fF
C601 a_220000_1376800# 0 171.00fF $ **FLOATING
C602 a_790714_1382800# 0 171.00fF $ **FLOATING
C603 a_787114_1376800# 0 3.06fF
C604 a_220000_1382800# 0 171.00fF $ **FLOATING
C605 a_216400_1376800# 0 3.06fF
C606 a_1326428_1382800# 0 3.06fF
C607 a_790714_1388800# 0 171.00fF $ **FLOATING
C608 a_755714_1382800# 0 3.06fF
C609 a_220000_1388800# 0 171.00fF $ **FLOATING
C610 a_790714_1394800# 0 171.00fF $ **FLOATING
C611 a_787114_1388800# 0 3.06fF
C612 a_220000_1394800# 0 171.00fF $ **FLOATING
C613 a_216400_1388800# 0 3.06fF
C614 a_1326428_1394800# 0 3.06fF
C615 a_790714_1400800# 0 171.00fF $ **FLOATING
C616 a_755714_1394800# 0 3.06fF
C617 a_220000_1400800# 0 171.00fF $ **FLOATING
C618 a_790714_1406800# 0 171.00fF $ **FLOATING
C619 a_787114_1400800# 0 3.06fF
C620 a_220000_1406800# 0 171.00fF $ **FLOATING
C621 a_216400_1400800# 0 3.06fF
C622 a_1326428_1406800# 0 3.06fF
C623 a_790714_1412800# 0 171.00fF $ **FLOATING
C624 a_755714_1406800# 0 3.06fF
C625 a_220000_1412800# 0 171.00fF $ **FLOATING
C626 a_790714_1418800# 0 171.00fF $ **FLOATING
C627 a_787114_1412800# 0 3.06fF
C628 a_220000_1418800# 0 171.00fF $ **FLOATING
C629 a_216400_1412800# 0 3.06fF
C630 a_1326428_1418800# 0 3.06fF
C631 a_790714_1424800# 0 171.00fF $ **FLOATING
C632 a_755714_1418800# 0 3.06fF
C633 a_220000_1424800# 0 171.00fF $ **FLOATING
C634 a_790714_1430800# 0 171.00fF $ **FLOATING
C635 a_787114_1424800# 0 3.06fF
C636 a_220000_1430800# 0 171.00fF $ **FLOATING
C637 a_216400_1424800# 0 3.06fF
C638 a_1326428_1430800# 0 3.06fF
C639 a_790714_1436800# 0 171.00fF $ **FLOATING
C640 a_755714_1430800# 0 3.06fF
C641 a_220000_1436800# 0 171.00fF $ **FLOATING
C642 a_790714_1442800# 0 171.00fF $ **FLOATING
C643 a_787114_1436800# 0 3.06fF
C644 a_220000_1442800# 0 171.00fF $ **FLOATING
C645 a_216400_1436800# 0 3.06fF
C646 a_1326428_1442800# 0 3.06fF
C647 a_790714_1448800# 0 171.00fF $ **FLOATING
C648 a_755714_1442800# 0 3.06fF
C649 a_220000_1448800# 0 171.00fF $ **FLOATING
C650 a_790714_1454800# 0 171.00fF $ **FLOATING
C651 a_787114_1448800# 0 3.06fF
C652 a_220000_1454800# 0 171.00fF $ **FLOATING
C653 a_216400_1448800# 0 3.06fF
C654 a_1326428_1454800# 0 3.06fF
C655 a_790714_1460800# 0 171.00fF $ **FLOATING
C656 a_755714_1454800# 0 3.06fF
C657 a_220000_1460800# 0 171.00fF $ **FLOATING
C658 a_790714_1466800# 0 171.00fF $ **FLOATING
C659 a_787114_1460800# 0 3.06fF
C660 a_220000_1466800# 0 171.00fF $ **FLOATING
C661 a_216400_1460800# 0 3.06fF
C662 a_1326428_1466800# 0 3.06fF
C663 a_790714_1472800# 0 171.00fF $ **FLOATING
C664 a_755714_1466800# 0 3.06fF
C665 a_220000_1472800# 0 171.00fF $ **FLOATING
C666 a_790714_1478800# 0 171.00fF $ **FLOATING
C667 a_787114_1472800# 0 3.06fF
C668 a_220000_1478800# 0 171.00fF $ **FLOATING
C669 a_216400_1472800# 0 3.06fF
C670 a_1326428_1478800# 0 3.06fF
C671 a_790714_1484800# 0 171.00fF $ **FLOATING
C672 a_755714_1478800# 0 3.06fF
C673 a_220000_1484800# 0 171.00fF $ **FLOATING
C674 a_790714_1490800# 0 171.00fF $ **FLOATING
C675 a_787114_1484800# 0 3.06fF
C676 a_220000_1490800# 0 171.00fF $ **FLOATING
C677 a_216400_1484800# 0 3.06fF
C678 a_1326428_1490800# 0 3.06fF
C679 a_790714_1496800# 0 171.00fF $ **FLOATING
C680 a_755714_1490800# 0 3.06fF
C681 a_220000_1496800# 0 171.00fF $ **FLOATING
C682 a_790714_1502800# 0 171.00fF $ **FLOATING
C683 a_787114_1496800# 0 3.06fF
C684 a_220000_1502800# 0 171.00fF $ **FLOATING
C685 a_216400_1496800# 0 3.06fF
C686 a_1326428_1502800# 0 3.06fF
C687 a_790714_1508800# 0 171.00fF $ **FLOATING
C688 a_755714_1502800# 0 3.06fF
C689 a_220000_1508800# 0 171.00fF $ **FLOATING
C690 a_790714_1514800# 0 171.00fF $ **FLOATING
C691 a_787114_1508800# 0 3.06fF
C692 a_220000_1514800# 0 171.00fF $ **FLOATING
C693 a_216400_1508800# 0 3.06fF
C694 a_1326428_1514800# 0 3.06fF
C695 a_790714_1520800# 0 171.00fF $ **FLOATING
C696 a_755714_1514800# 0 3.06fF
C697 a_220000_1520800# 0 171.00fF $ **FLOATING
C698 a_790714_1526800# 0 171.00fF $ **FLOATING
C699 a_787114_1520800# 0 3.06fF
C700 a_220000_1526800# 0 171.00fF $ **FLOATING
C701 a_216400_1520800# 0 3.06fF
C702 a_1326428_1526800# 0 3.06fF
C703 a_790714_1532800# 0 171.00fF $ **FLOATING
C704 a_755714_1526800# 0 3.06fF
C705 a_220000_1532800# 0 171.00fF $ **FLOATING
C706 a_790714_1538800# 0 171.00fF $ **FLOATING
C707 a_787114_1532800# 0 3.06fF
C708 a_220000_1538800# 0 171.00fF $ **FLOATING
C709 a_216400_1532800# 0 3.06fF
C710 a_1326428_1538800# 0 3.06fF
C711 a_790714_1544800# 0 171.00fF $ **FLOATING
C712 a_755714_1538800# 0 3.06fF
C713 a_220000_1544800# 0 171.00fF $ **FLOATING
C714 a_790714_1550800# 0 171.00fF $ **FLOATING
C715 a_787114_1544800# 0 3.06fF
C716 a_220000_1550800# 0 171.00fF $ **FLOATING
C717 a_216400_1544800# 0 3.06fF
C718 a_1326428_1550800# 0 3.06fF
C719 a_790714_1556800# 0 171.00fF $ **FLOATING
C720 a_755714_1550800# 0 3.06fF
C721 a_220000_1556800# 0 171.00fF $ **FLOATING
C722 a_790714_1562800# 0 171.00fF $ **FLOATING
C723 a_787114_1556800# 0 3.06fF
C724 a_220000_1562800# 0 171.00fF $ **FLOATING
C725 a_216400_1556800# 0 3.06fF
C726 a_1326428_1562800# 0 3.06fF
C727 a_790714_1568800# 0 171.00fF $ **FLOATING
C728 a_755714_1562800# 0 3.06fF
C729 a_220000_1568800# 0 171.00fF $ **FLOATING
C730 a_790714_1574800# 0 171.00fF $ **FLOATING
C731 a_787114_1568800# 0 3.06fF
C732 a_220000_1574800# 0 171.00fF $ **FLOATING
C733 a_216400_1568800# 0 3.06fF
C734 a_1326428_1574800# 0 3.06fF
C735 a_790714_1580800# 0 171.00fF $ **FLOATING
C736 a_755714_1574800# 0 3.06fF
C737 a_220000_1580800# 0 171.00fF $ **FLOATING
C738 a_790714_1586800# 0 171.00fF $ **FLOATING
C739 a_787114_1580800# 0 3.06fF
C740 a_220000_1586800# 0 171.00fF $ **FLOATING
C741 a_216400_1580800# 0 3.06fF
C742 a_1326428_1586800# 0 3.06fF
C743 a_790714_1592800# 0 171.00fF $ **FLOATING
C744 a_755714_1586800# 0 3.06fF
C745 a_220000_1592800# 0 171.00fF $ **FLOATING
C746 a_790714_1598800# 0 171.00fF $ **FLOATING
C747 a_787114_1592800# 0 3.06fF
C748 a_220000_1598800# 0 171.00fF $ **FLOATING
C749 a_216400_1592800# 0 3.06fF
C750 a_1326428_1598800# 0 3.06fF
C751 a_790714_1604800# 0 171.00fF $ **FLOATING
C752 a_755714_1598800# 0 3.06fF
C753 a_220000_1604800# 0 171.00fF $ **FLOATING
C754 a_790714_1610800# 0 171.00fF $ **FLOATING
C755 a_787114_1604800# 0 3.06fF
C756 a_220000_1610800# 0 171.00fF $ **FLOATING
C757 a_216400_1604800# 0 3.06fF
C758 a_1326428_1610800# 0 3.06fF
C759 a_790714_1616800# 0 171.00fF $ **FLOATING
C760 a_755714_1610800# 0 3.06fF
C761 a_220000_1616800# 0 171.00fF $ **FLOATING
C762 a_790714_1622800# 0 171.00fF $ **FLOATING
C763 a_787114_1616800# 0 3.06fF
C764 a_220000_1622800# 0 171.00fF $ **FLOATING
C765 a_216400_1616800# 0 3.06fF
C766 a_1326428_1622800# 0 3.06fF
C767 a_790714_1628800# 0 171.00fF $ **FLOATING
C768 a_755714_1622800# 0 3.06fF
C769 a_220000_1628800# 0 171.00fF $ **FLOATING
C770 a_790714_1634800# 0 171.00fF $ **FLOATING
C771 a_787114_1628800# 0 3.06fF
C772 a_220000_1634800# 0 171.00fF $ **FLOATING
C773 a_216400_1628800# 0 3.06fF
C774 a_1326428_1634800# 0 3.06fF
C775 a_790714_1640800# 0 171.00fF $ **FLOATING
C776 a_755714_1634800# 0 3.06fF
C777 a_220000_1640800# 0 171.00fF $ **FLOATING
C778 a_790714_1646800# 0 171.00fF $ **FLOATING
C779 a_787114_1640800# 0 3.06fF
C780 a_220000_1646800# 0 171.00fF $ **FLOATING
C781 a_216400_1640800# 0 3.06fF
C782 a_1326428_1646800# 0 3.06fF
C783 a_790714_1652800# 0 171.00fF $ **FLOATING
C784 a_755714_1646800# 0 3.06fF
C785 a_220000_1652800# 0 171.00fF $ **FLOATING
C786 a_790714_1658800# 0 171.00fF $ **FLOATING
C787 a_787114_1652800# 0 3.06fF
C788 a_220000_1658800# 0 171.00fF $ **FLOATING
C789 a_216400_1652800# 0 3.06fF
C790 a_1326428_1658800# 0 3.06fF
C791 a_790714_1664800# 0 171.00fF $ **FLOATING
C792 a_755714_1658800# 0 3.06fF
C793 a_220000_1664800# 0 171.00fF $ **FLOATING
C794 a_790714_1670800# 0 171.00fF $ **FLOATING
C795 a_787114_1664800# 0 3.06fF
C796 a_220000_1670800# 0 171.00fF $ **FLOATING
C797 a_216400_1664800# 0 3.06fF
C798 a_1326428_1670800# 0 3.06fF
C799 a_790714_1676800# 0 171.00fF $ **FLOATING
C800 a_755714_1670800# 0 3.06fF
C801 a_220000_1676800# 0 171.00fF $ **FLOATING
C802 a_790714_1682800# 0 171.00fF $ **FLOATING
C803 a_787114_1676800# 0 3.06fF
C804 a_220000_1682800# 0 171.00fF $ **FLOATING
C805 a_216400_1676800# 0 3.06fF
C806 a_1326428_1682800# 0 3.06fF
C807 a_790714_1688800# 0 171.00fF $ **FLOATING
C808 a_755714_1682800# 0 3.06fF
C809 a_220000_1688800# 0 171.00fF $ **FLOATING
C810 a_790714_1694800# 0 171.00fF $ **FLOATING
C811 a_787114_1688800# 0 3.06fF
C812 a_220000_1694800# 0 171.00fF $ **FLOATING
C813 a_216400_1688800# 0 3.06fF
C814 a_1326428_1694800# 0 3.06fF
C815 a_790714_1700800# 0 171.00fF $ **FLOATING
C816 a_755714_1694800# 0 3.06fF
C817 a_220000_1700800# 0 171.00fF $ **FLOATING
C818 a_790714_1706800# 0 171.00fF $ **FLOATING
C819 a_787114_1700800# 0 3.06fF
C820 a_220000_1706800# 0 171.00fF $ **FLOATING
C821 a_216400_1700800# 0 3.06fF
C822 a_1326428_1706800# 0 3.06fF
C823 a_790714_1712800# 0 171.00fF $ **FLOATING
C824 a_755714_1706800# 0 3.06fF
C825 a_220000_1712800# 0 171.00fF $ **FLOATING
C826 a_790714_1718800# 0 171.00fF $ **FLOATING
C827 a_787114_1712800# 0 3.06fF
C828 a_220000_1718800# 0 171.00fF $ **FLOATING
C829 a_216400_1712800# 0 3.06fF
C830 a_1326428_1718800# 0 3.06fF
C831 a_790714_1724800# 0 171.00fF $ **FLOATING
C832 a_755714_1718800# 0 3.06fF
C833 a_220000_1724800# 0 171.00fF $ **FLOATING
C834 a_790714_1730800# 0 171.00fF $ **FLOATING
C835 a_787114_1724800# 0 3.06fF
C836 a_220000_1730800# 0 171.00fF $ **FLOATING
C837 a_216400_1724800# 0 3.06fF
C838 a_1326428_1730800# 0 3.06fF
C839 a_790714_1736800# 0 171.00fF $ **FLOATING
C840 a_755714_1730800# 0 3.06fF
C841 a_220000_1736800# 0 171.00fF $ **FLOATING
C842 a_790714_1742800# 0 171.00fF $ **FLOATING
C843 a_787114_1736800# 0 3.06fF
C844 a_220000_1742800# 0 171.00fF $ **FLOATING
C845 a_216400_1736800# 0 3.06fF
C846 a_1326428_1742800# 0 3.06fF
C847 a_790714_1748800# 0 171.00fF $ **FLOATING
C848 a_755714_1742800# 0 3.06fF
C849 a_220000_1748800# 0 171.00fF $ **FLOATING
C850 a_790714_1754800# 0 171.00fF $ **FLOATING
C851 a_787114_1748800# 0 3.06fF
C852 a_220000_1754800# 0 171.00fF $ **FLOATING
C853 a_216400_1748800# 0 3.06fF
C854 a_1326428_1754800# 0 3.06fF
C855 a_790714_1760800# 0 171.00fF $ **FLOATING
C856 a_755714_1754800# 0 3.06fF
C857 a_220000_1760800# 0 171.00fF $ **FLOATING
C858 a_790714_1766800# 0 171.00fF $ **FLOATING
C859 a_787114_1760800# 0 3.06fF
C860 a_220000_1766800# 0 171.00fF $ **FLOATING
C861 a_216400_1760800# 0 3.06fF
C862 a_1326428_1766800# 0 3.06fF
C863 a_790714_1772800# 0 171.00fF $ **FLOATING
C864 a_755714_1766800# 0 3.06fF
C865 a_220000_1772800# 0 171.00fF $ **FLOATING
C866 a_790714_1778800# 0 171.00fF $ **FLOATING
C867 a_787114_1772800# 0 3.06fF
C868 a_220000_1778800# 0 171.00fF $ **FLOATING
C869 a_216400_1772800# 0 3.06fF
C870 a_1326428_1778800# 0 3.06fF
C871 a_790714_1784800# 0 171.00fF $ **FLOATING
C872 a_755714_1778800# 0 3.06fF
C873 a_220000_1784800# 0 171.00fF $ **FLOATING
C874 a_790714_1790800# 0 171.00fF $ **FLOATING
C875 a_787114_1784800# 0 3.06fF
C876 a_220000_1790800# 0 171.00fF $ **FLOATING
C877 a_216400_1784800# 0 3.06fF
C878 a_1326428_1790800# 0 3.06fF
C879 a_790714_1796800# 0 171.00fF $ **FLOATING
C880 a_755714_1790800# 0 3.06fF
C881 a_220000_1796800# 0 171.00fF $ **FLOATING
C882 a_790714_1802800# 0 171.00fF $ **FLOATING
C883 a_787114_1796800# 0 3.06fF
C884 a_220000_1802800# 0 171.00fF $ **FLOATING
C885 a_216400_1796800# 0 3.06fF
C886 a_1326428_1802800# 0 3.06fF
C887 a_790714_1808800# 0 171.00fF $ **FLOATING
C888 a_755714_1802800# 0 3.06fF
C889 a_220000_1808800# 0 171.00fF $ **FLOATING
C890 a_790714_1814800# 0 171.00fF $ **FLOATING
C891 a_787114_1808800# 0 3.06fF
C892 a_220000_1814800# 0 171.00fF $ **FLOATING
C893 a_216400_1808800# 0 3.06fF
C894 a_1326428_1814800# 0 3.06fF
C895 a_790714_1820800# 0 171.00fF $ **FLOATING
C896 a_755714_1814800# 0 3.06fF
C897 a_220000_1820800# 0 171.00fF $ **FLOATING
C898 a_790714_1826800# 0 171.00fF $ **FLOATING
C899 a_787114_1820800# 0 3.06fF
C900 a_220000_1826800# 0 171.00fF $ **FLOATING
C901 a_216400_1820800# 0 3.06fF
C902 a_1326428_1826800# 0 3.06fF
C903 a_790714_1832800# 0 171.00fF $ **FLOATING
C904 a_755714_1826800# 0 3.06fF
C905 a_220000_1832800# 0 171.00fF $ **FLOATING
C906 a_790714_1838800# 0 171.00fF $ **FLOATING
C907 a_787114_1832800# 0 3.06fF
C908 a_220000_1838800# 0 171.00fF $ **FLOATING
C909 a_216400_1832800# 0 3.06fF
C910 a_1326428_1838800# 0 3.06fF
C911 a_790714_1844800# 0 171.00fF $ **FLOATING
C912 a_755714_1838800# 0 3.06fF
C913 a_220000_1844800# 0 171.00fF $ **FLOATING
C914 a_790714_1850800# 0 171.00fF $ **FLOATING
C915 a_787114_1844800# 0 3.06fF
C916 a_220000_1850800# 0 171.00fF $ **FLOATING
C917 a_216400_1844800# 0 3.06fF
C918 a_1326428_1850800# 0 3.06fF
C919 a_790714_1856800# 0 171.00fF $ **FLOATING
C920 a_755714_1850800# 0 3.06fF
C921 a_220000_1856800# 0 171.00fF $ **FLOATING
C922 a_790714_1862800# 0 171.00fF $ **FLOATING
C923 a_787114_1856800# 0 3.06fF
C924 a_220000_1862800# 0 171.00fF $ **FLOATING
C925 a_216400_1856800# 0 3.06fF
C926 a_1326428_1862800# 0 3.06fF
C927 a_790714_1868800# 0 171.00fF $ **FLOATING
C928 a_755714_1862800# 0 3.06fF
C929 a_220000_1868800# 0 171.00fF $ **FLOATING
C930 a_790714_1874800# 0 171.00fF $ **FLOATING
C931 a_787114_1868800# 0 3.06fF
C932 a_220000_1874800# 0 171.00fF $ **FLOATING
C933 a_216400_1868800# 0 3.06fF
C934 a_1326428_1874800# 0 3.06fF
C935 a_790714_1880800# 0 171.00fF $ **FLOATING
C936 a_755714_1874800# 0 3.06fF
C937 a_220000_1880800# 0 171.00fF $ **FLOATING
C938 a_790714_1886800# 0 171.00fF $ **FLOATING
C939 a_787114_1880800# 0 3.06fF
C940 a_220000_1886800# 0 171.00fF $ **FLOATING
C941 a_216400_1880800# 0 3.06fF
C942 a_1326428_1886800# 0 3.06fF
C943 a_790714_1892800# 0 171.00fF $ **FLOATING
C944 a_755714_1886800# 0 3.06fF
C945 a_220000_1892800# 0 171.00fF $ **FLOATING
C946 a_790714_1898800# 0 171.00fF $ **FLOATING
C947 a_787114_1892800# 0 3.06fF
C948 a_220000_1898800# 0 171.00fF $ **FLOATING
C949 a_216400_1892800# 0 3.06fF
C950 a_1326428_1898800# 0 3.06fF
C951 a_790714_1904800# 0 171.00fF $ **FLOATING
C952 a_755714_1898800# 0 3.06fF
C953 a_220000_1904800# 0 171.00fF $ **FLOATING
C954 a_790714_1910800# 0 171.00fF $ **FLOATING
C955 a_787114_1904800# 0 3.06fF
C956 a_220000_1910800# 0 171.00fF $ **FLOATING
C957 a_216400_1904800# 0 3.06fF
C958 a_1326428_1910800# 0 3.06fF
C959 a_790714_1916800# 0 171.00fF $ **FLOATING
C960 a_755714_1910800# 0 3.06fF
C961 a_220000_1916800# 0 171.00fF $ **FLOATING
C962 a_790714_1922800# 0 171.00fF $ **FLOATING
C963 a_787114_1916800# 0 3.06fF
C964 a_220000_1922800# 0 171.00fF $ **FLOATING
C965 a_216400_1916800# 0 3.06fF
C966 a_1326428_1922800# 0 3.06fF
C967 a_790714_1928800# 0 171.00fF $ **FLOATING
C968 a_755714_1922800# 0 3.06fF
C969 a_220000_1928800# 0 171.00fF $ **FLOATING
C970 a_790714_1934800# 0 171.00fF $ **FLOATING
C971 a_787114_1928800# 0 3.06fF
C972 a_220000_1934800# 0 171.00fF $ **FLOATING
C973 a_216400_1928800# 0 3.06fF
C974 a_1326428_1934800# 0 3.06fF
C975 a_790714_1940800# 0 171.00fF $ **FLOATING
C976 a_755714_1934800# 0 3.06fF
C977 a_220000_1940800# 0 171.00fF $ **FLOATING
C978 a_790714_1946800# 0 171.00fF $ **FLOATING
C979 a_787114_1940800# 0 3.06fF
C980 a_220000_1946800# 0 171.00fF $ **FLOATING
C981 a_216400_1940800# 0 3.06fF
C982 a_1326428_1946800# 0 3.06fF
C983 a_790714_1952800# 0 171.00fF $ **FLOATING
C984 a_755714_1946800# 0 3.06fF
C985 a_220000_1952800# 0 171.00fF $ **FLOATING
C986 a_790714_1958800# 0 171.00fF $ **FLOATING
C987 a_787114_1952800# 0 3.06fF
C988 a_220000_1958800# 0 171.00fF $ **FLOATING
C989 a_216400_1952800# 0 3.06fF
C990 a_1326428_1958800# 0 3.06fF
C991 a_790714_1964800# 0 171.00fF $ **FLOATING
C992 a_755714_1958800# 0 3.06fF
C993 a_220000_1964800# 0 171.00fF $ **FLOATING
C994 a_790714_1970800# 0 171.00fF $ **FLOATING
C995 a_787114_1964800# 0 3.06fF
C996 a_220000_1970800# 0 171.00fF $ **FLOATING
C997 a_216400_1964800# 0 3.06fF
C998 a_1326428_1970800# 0 3.06fF
C999 a_790714_1976800# 0 171.00fF $ **FLOATING
C1000 a_755714_1970800# 0 3.06fF
C1001 a_220000_1976800# 0 171.00fF $ **FLOATING
C1002 a_790714_1982800# 0 171.00fF $ **FLOATING
C1003 a_787114_1976800# 0 3.06fF
C1004 a_220000_1982800# 0 171.00fF $ **FLOATING
C1005 a_216400_1976800# 0 3.06fF
C1006 a_1326428_1982800# 0 3.06fF
C1007 a_790714_1988800# 0 171.00fF $ **FLOATING
C1008 a_755714_1982800# 0 3.06fF
C1009 a_220000_1988800# 0 171.00fF $ **FLOATING
C1010 a_790714_1994800# 0 171.00fF $ **FLOATING
C1011 a_787114_1988800# 0 3.06fF
C1012 a_220000_1994800# 0 171.00fF $ **FLOATING
C1013 a_216400_1988800# 0 3.06fF
C1014 a_1326428_1994800# 0 3.06fF
C1015 a_790714_2000800# 0 171.00fF $ **FLOATING
C1016 a_755714_1994800# 0 3.06fF
C1017 a_220000_2000800# 0 171.00fF $ **FLOATING
C1018 a_790714_2006800# 0 171.00fF $ **FLOATING
C1019 a_787114_2000800# 0 3.06fF
C1020 a_220000_2006800# 0 171.00fF $ **FLOATING
C1021 a_216400_2000800# 0 3.06fF
C1022 a_1326428_2006800# 0 3.06fF
C1023 a_790714_2012800# 0 171.00fF $ **FLOATING
C1024 a_755714_2006800# 0 3.06fF
C1025 a_220000_2012800# 0 171.00fF $ **FLOATING
C1026 a_216400_2012800# 0 159.49fF
.ends
