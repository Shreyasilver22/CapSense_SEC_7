Differential closed-loop step; input CM 2.5 V, output target VDD/2
.include "../models/scl08_models.inc"
.include "../models/ota_cm2p5_C.spice"
.temp 27
.options reltol=1e-5 vntol=1e-8 abstol=1e-12 numdgt=12 method=gear maxord=2
VDD vdd 0 5
IREF vdd bn 3.5u
VCM vcm 0 2.5
VBN vbn 0 3
VBP vbp vdd -2.2
XOTA inp inn op om vdd 0 bn vcm vbn vbp ota_telescopic_cm2p5
CLP op 0 5p
CLM om 0 5p
EOD od 0 op om 1
VICM icm 0 2.5
EIP inp icm cmd od 0.5
EIM inn icm od cmd 0.5
VCMD cmd 0 PWL(0 -1 10u -1 10.01u 1 30u 1 30.01u -1 50u -1)
.control
set wr_singlescale
set wr_vecnames
op
print v(op) v(om) i(vdd)
tran 10n 50u
wrdata transient.dat v(op) v(om) v(inp) v(inn) i(vdd) v(cmd)
write ota_cm2p5_transient.raw v(op) v(om) v(inp) v(inn) v(cmd)
quit
.endc
.end
