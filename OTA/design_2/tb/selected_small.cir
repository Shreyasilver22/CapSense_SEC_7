Tuned SCL800 OTA compensation check metal_8p_top_n2
.include "../spice/models.inc"
.include "../designs/capacitors.lib.spice"
.include "../designs/metal_8p_top_n2.inc"
.temp 27
.options reltol=1e-5 vntol=1e-8 abstol=1e-12 numdgt=12
VDD vdd 0 5
IREF vdd bias 2.5u
CL out 0 5p
XU inp inn out vdd 0 bias ota_tuned LI=2.4u LM=3.2u LO=3.2u K=4 CC=8p
VIN inp 0 dc 2.5 pulse(2.5 2.6 10u 10n 10n 40u 80u)
VFB inn out 0
.control
set wr_singlescale
set wr_vecnames
tran 5n 90u
wrdata ../results/selected_small.dat v(inp) v(out) i(vdd)
quit
.endc
.end
