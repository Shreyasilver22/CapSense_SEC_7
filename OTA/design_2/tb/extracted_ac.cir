Tuned SCL800 OTA compensation check metal_8p_top_n2
.include "../spice/models.inc"
.include "../designs/capacitors.lib.spice"
.include "../designs/extracted.inc"
.temp 27
.options reltol=1e-5 vntol=1e-8 abstol=1e-12 numdgt=12
VDD vdd 0 5
IREF vdd bias 2.5u
CL out 0 5p
XU inp inn out vdd 0 bias ota_extracted_cc
VIN inp 0 dc 2.5 ac 1
LDC out inn 1e12
CAC inn 0 1e12
.control
set wr_singlescale
set wr_vecnames
op
print v(out) i(vdd)
ac dec 150 1 1G
let gain_db=db(v(out))
let phase_deg=180/PI*cph(v(out))
wrdata ../results/selected_ac.dat gain_db phase_deg
quit
.endc
.end
