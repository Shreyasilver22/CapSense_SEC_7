.model capsense_phase_gen_cosim d_cosim simulation="../runtime/lib/ngspice/ivlng.so" sim_args=["capsense_phase_gen.vvp"] lib_args=["../runtime/lib/libvvp.so" "../runtime/lib/ngspice/ivlng.vpi" "vvp.log"]
.model capsense_adc adc_bridge(in_low=2.5 in_high=2.5)
.model capsense_dac dac_bridge(out_low=0 out_high=5 out_undef=2.5 input_load=1p t_rise=1n t_fall=1n)
