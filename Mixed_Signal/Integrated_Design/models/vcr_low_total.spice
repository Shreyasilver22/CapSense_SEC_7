* Same extracted network as CMFB revision 2; external bias is changed in the testbench.
* NGSPICE file created from ota_telescopic_cm2p5.ext - technology: SCL_CP8D
.subckt ota_telescopic_cm2p5 INP INN OUTP OUTM VDD VSS IREF VCM VBN VBP
M1000 VDD OUTM a_166200_473000# VSS N w=20u l=1.6u ad=90.00001p pd=49u as=90.00001p ps=49u
M1001 OUTP a_163000_528900# OUTP OUTP P w=20u l=10u ad=90.00001p pd=49u as=-1.86497n ps=1.305m
M1002 OUTP a_163000_528900# OUTP OUTP P w=20u l=10u ad=90.00001p pd=49u as=-0 ps=0
M1003 a_163000_868700# IREF VSS VSS N w=11.429u l=3.2u ad=51.4305p pd=31.858u as=51.4305p ps=31.858u
M1004 OUTP a_163000_528900# OUTP OUTP P w=20u l=10u ad=90.00001p pd=49u as=-0 ps=0
M1006 a_200200_868700# a_200200_868700# VSS VSS N w=10u l=3.2u ad=45p pd=29u as=45p ps=29u
M1007 a_239000_71400# INN a_166200_71400# VSS N w=15u l=2.4u ad=67.50001p pd=39u as=67.50001p ps=39u
M1008 a_158500_217600# a_163000_528900# VDD VDD P w=40u l=3.2u ad=0.18n pd=89u as=0.18n ps=89u
M1009 OUTM a_163000_528900# OUTM OUTM P w=20u l=10u ad=90.00001p pd=49u as=-1.86497n ps=1.305m
M1010 OUTP a_163000_528900# OUTP OUTP P w=20u l=10u ad=90.00001p pd=49u as=-0 ps=0
M1011 OUTM a_163000_528900# OUTM OUTM P w=20u l=10u ad=90.00001p pd=49u as=-0 ps=0
M1012 OUTM a_163000_528900# OUTM OUTM P w=20u l=10u ad=90.00001p pd=49u as=-0 ps=0
M1013 OUTM a_163000_528900# OUTM OUTM P w=20u l=10u ad=90.00001p pd=49u as=-0 ps=0
M1014 a_274600_868700# a_274600_868700# VSS VSS N w=10u l=3.2u ad=45p pd=29u as=45p ps=29u
M1015 OUTP VBN a_239000_71400# VSS N w=30u l=2.4u ad=0.135n pd=69u as=0.135n ps=69u
M1018 VDD OUTP a_158500_329400# VSS N w=20u l=1.6u ad=90.00001p pd=49u as=90.00001p ps=49u
M1019 a_163000_916100# a_163000_916100# VDD VDD P w=10u l=3.2u ad=45p pd=29u as=45p ps=29u
M1021 OUTP a_163000_528900# OUTP OUTP P w=20u l=10u ad=90.00001p pd=49u as=-0 ps=0
M1022 OUTP a_163000_528900# OUTP OUTP P w=20u l=10u ad=90.00001p pd=49u as=-0 ps=0
M1023 VDD VCM a_158500_401200# VSS N w=20u l=1.6u ad=90.00001p pd=49u as=90.00001p ps=49u
M1025 OUTP a_163000_528900# OUTP OUTP P w=20u l=10u ad=90.00001p pd=49u as=-0 ps=0
M1026 a_166200_473000# IREF VSS VSS N w=20u l=3.2u ad=90.00001p pd=49u as=90.00001p ps=49u
M1027 a_163000_528900# a_200200_868700# VSS VSS N w=10u l=3.2u ad=45p pd=29u as=45p ps=29u
M1028 a_200200_868700# a_161400_1209400# a_166200_870200# VDD P w=5u l=2.4u ad=22.5p pd=19u as=22.5p ps=19u
M1032 a_163000_916100# a_274600_868700# VSS VSS N w=10u l=3.2u ad=45p pd=29u as=45p ps=29u
M1033 OUTM VBN a_202600_71400# VSS N w=30u l=2.4u ad=0.135n pd=69u as=0.135n ps=69u
M1034 a_158500_329400# IREF VSS VSS N w=20u l=3.2u ad=90.00001p pd=49u as=90.00001p ps=49u
M1036 VDD VCM a_158500_401200# VSS N w=20u l=1.6u ad=90.00001p pd=49u as=90.00001p ps=49u
M1039 a_166200_71400# IREF VSS VSS N w=80.00001u l=3.2u ad=0.36n pd=0.169m as=0.36n ps=0.169m
M1040 a_158500_401200# IREF VSS VSS N w=20u l=3.2u ad=90.00001p pd=49u as=90.00001p ps=49u
M1041 OUTP VBP a_158500_217600# VDD P w=60u l=2.4u ad=0.27n pd=0.129m as=0.27n ps=0.129m
M1042 OUTM VBP a_202600_217600# VDD P w=60u l=2.4u ad=0.27n pd=0.129m as=0.27n ps=0.129m
M1043 a_163000_868700# a_163000_868700# VDD VDD P w=20u l=3.2u ad=90.00001p pd=49u as=90.00001p ps=49u
M1044 a_166200_870200# a_163000_868700# VDD VDD P w=10u l=3.2u ad=45p pd=29u as=45p ps=29u
M1045 a_202600_217600# a_163000_528900# VDD VDD P w=40u l=3.2u ad=0.18n pd=89u as=0.18n ps=89u
M1046 OUTM a_163000_528900# OUTM OUTM P w=20u l=10u ad=90.00001p pd=49u as=-0 ps=0
M1047 OUTM a_163000_528900# OUTM OUTM P w=20u l=10u ad=90.00001p pd=49u as=-0 ps=0
M1049 OUTM a_163000_528900# OUTM OUTM P w=20u l=10u ad=90.00001p pd=49u as=-0 ps=0
M1050 OUTM a_163000_528900# OUTM OUTM P w=20u l=10u ad=90.00001p pd=49u as=-0 ps=0
M1051 OUTM a_163000_528900# OUTM OUTM P w=20u l=10u ad=90.00001p pd=49u as=-0 ps=0
M1052 OUTP a_163000_528900# OUTP OUTP P w=20u l=10u ad=90.00001p pd=49u as=-0 ps=0
M1053 IREF IREF VSS VSS N w=20u l=3.2u ad=90.00001p pd=49u as=90.00001p ps=49u
M1054 OUTP a_163000_528900# OUTP OUTP P w=20u l=10u ad=90.00001p pd=49u as=-0 ps=0
M1055 OUTM a_163000_528900# OUTM OUTM P w=20u l=10u ad=90.00001p pd=49u as=-0 ps=0
M1056 OUTP a_163000_528900# OUTP OUTP P w=20u l=10u ad=90.00001p pd=49u as=-0 ps=0
M1057 OUTM a_163000_528900# OUTM OUTM P w=20u l=10u ad=90.00001p pd=49u as=-0 ps=0
M1058 OUTP a_163000_528900# OUTP OUTP P w=20u l=10u ad=90.00001p pd=49u as=-0 ps=0
M1059 a_202600_71400# INP a_166200_71400# VSS N w=15u l=2.4u ad=67.50001p pd=39u as=67.50001p ps=39u
M1060 OUTM a_163000_528900# OUTM OUTM P w=20u l=10u ad=90.00001p pd=49u as=-0 ps=0
M1061 OUTP a_163000_528900# OUTP OUTP P w=20u l=10u ad=90.00001p pd=49u as=-0 ps=0
M1062 a_274600_868700# a_158500_401200# a_166200_870200# VDD P w=5u l=2.4u ad=22.5p pd=19u as=22.5p ps=19u
M1063 a_163000_528900# a_163000_916100# VDD VDD P w=10u l=3.2u ad=45p pd=29u as=45p ps=29u
M1064 VDD OUTM a_166200_473000# VSS N w=20u l=1.6u ad=90.00001p pd=49u as=90.00001p ps=49u
M1065 VDD OUTP a_158500_329400# VSS N w=20u l=1.6u ad=90.00001p pd=49u as=90.00001p ps=49u
C2 a_158500_401200# VDD 5.75039f
C3 a_202600_217600# a_202600_71400# 0.64513f
C6 a_239000_71400# VSS 1.72421f
C8 a_274600_868700# OUTM 1.93539f
C11 a_166200_71400# IREF 1.03977f
C15 a_161400_1209400# a_163000_868700# 1.14736f
C17 a_163000_528900# a_158500_401200# 3.08143f
C18 a_200200_868700# a_274600_868700# 1.46861f
C19 a_163000_868700# a_166200_870200# 1.51542f
C20 OUTM VBN 0.82212f
C21 VDD INP 0.28651f
C22 OUTP VBP 1.95405f
C23 VSS VCM 2.2934f
C25 a_163000_916100# VSS 2.61092f
C29 a_202600_71400# INN 0.28651f
C30 a_166200_473000# IREF 2.39477f
C35 a_158500_329400# VCM 1.43255f
C38 a_202600_217600# VDD 2.75151f
C39 a_166200_71400# a_239000_71400# 0.92537f
C44 a_158500_401200# OUTM 2.6507f
C45 a_239000_71400# IREF 0.28651f
C50 a_161400_1209400# a_274600_868700# 0.3252f
C52 a_163000_528900# a_202600_217600# 0.65988f
C53 a_200200_868700# a_158500_401200# 0.28651f
C54 a_274600_868700# a_166200_870200# 1.25354f
C56 a_163000_868700# VSS 3.1902f
C58 a_158500_217600# VBP 0.92297f
C62 OUTM INP 0.28651f
C63 VDD INN 0.28651f
C64 VSS VBP 3.15161f
C65 IREF VCM 0.59669f
C66 OUTP VBN 0.5356f
C69 a_166200_473000# VCM 0.28651f
C75 a_202600_71400# VDD 0.28651f
C76 a_158500_329400# VBP 0.32256f
C78 a_202600_217600# OUTM 0.90578f
C85 a_158500_401200# OUTP 0.9677f
C86 a_161400_1209400# a_158500_401200# 0.28651f
C88 a_166200_870200# a_158500_401200# 0.38238f
C91 a_274600_868700# VSS 3.56719f
C95 a_166200_71400# VBP 0.31018f
C96 a_163000_868700# IREF 0.39173f
C100 VSS VBN 1.71906f
C102 OUTP INP 0.28651f
C103 OUTM INN 0.28651f
C104 IREF VBP 1.14604f
C105 a_166200_473000# a_163000_868700# 0.00264f
C112 a_202600_71400# OUTM 0.70379f
C117 a_202600_217600# OUTP 1.50466f
C121 a_163000_528900# VDD 13.8819f
C123 a_158500_401200# VSS 6.44977f
C125 a_239000_71400# VBP 0.28651f
C128 a_274600_868700# IREF 0.32256f
C131 a_166200_71400# VBN 0.57302f
C134 a_158500_329400# a_158500_401200# 0.64909f
C135 a_163000_916100# a_163000_868700# 0.32256f
C139 IREF VBN 0.28783f
C140 OUTP INN 0.28651f
C141 VSS INP 0.28651f
C145 VDD OUTM 5.43802f
C150 a_202600_71400# OUTP 0.28651f
C154 a_158500_217600# a_202600_217600# 0.28651f
C155 a_200200_868700# VDD 2.62168f
C157 a_202600_217600# VSS 3.36794f
C160 a_163000_528900# OUTM 19.2685f
C162 a_158500_401200# IREF 3.18412f
C165 a_239000_71400# VBN 0.91104f
C168 a_163000_916100# a_274600_868700# 1.05056f
C169 a_163000_528900# a_200200_868700# 1.22891f
C170 a_158500_329400# a_202600_217600# 0.32256f
C171 a_166200_473000# a_158500_401200# 1.00264f
C174 a_166200_71400# INP 0.47348f
C179 VSS INN 0.28651f
C180 IREF INP 0.28651f
C187 VDD OUTP 7.38011f
C188 a_161400_1209400# VDD 1.79117f
C190 a_202600_217600# a_166200_71400# 0.9677f
C191 a_166200_870200# VDD 2.64504f
C193 a_202600_71400# VSS 1.72421f
C197 a_200200_868700# OUTM 1.71906f
C199 a_202600_217600# IREF 1.1821f
C201 a_163000_528900# OUTP 20.4286f
C203 a_161400_1209400# a_163000_528900# 1.1821f
C206 a_158500_401200# VCM 2.10466f
C207 a_163000_528900# a_166200_870200# 1.14604f
C208 a_163000_868700# a_274600_868700# 1.54072f
C209 a_239000_71400# INP 0.28651f
C214 a_166200_71400# INN 0.47348f
C218 IREF INN 0.28651f
C219 VBP VBN 0.57302f
C225 a_158500_217600# VDD 2.14243f
C226 a_202600_217600# a_239000_71400# 0.64513f
C227 a_166200_71400# a_202600_71400# 0.92537f
C228 OUTM OUTP 4.34692f
C229 VDD VSS 11.5455f
C231 a_161400_1209400# OUTM 1.71906f
C232 a_166200_870200# OUTM 1.71906f
C236 a_202600_71400# IREF 0.28651f
C239 a_161400_1209400# a_200200_868700# 0.66623f
C241 a_163000_528900# a_158500_217600# 0.94639f
C242 a_163000_868700# a_158500_401200# 0.28651f
C243 a_200200_868700# a_166200_870200# 1.4456f
C244 a_158500_329400# VDD 7.75596f
C246 a_163000_528900# VSS 7.80223f
C251 a_239000_71400# INN 0.418f
C257 a_158500_329400# a_163000_528900# 3.29665f
C260 a_166200_71400# VDD 0.28651f
C261 a_202600_71400# a_239000_71400# 0.57302f
C264 VBP INP 0.28651f
C269 OUTM VSS 4.74013f
C270 VDD IREF 8.14038f
C272 a_161400_1209400# a_166200_870200# 0.42971f
C274 a_274600_868700# a_158500_401200# 0.35605f
C275 a_166200_473000# VDD 6.00084f
C278 a_200200_868700# VSS 3.49508f
C280 a_202600_217600# VBP 1.53205f
C281 a_158500_329400# OUTM 2.36419f
C284 a_163000_528900# IREF 2.8651f
C289 a_166200_473000# a_163000_528900# 3.12013f
C293 a_239000_71400# VDD 0.28651f
C297 a_166200_71400# OUTM 0.57302f
C299 VBP INN 0.28651f
C300 VBN INP 0.28651f
C303 a_158500_217600# OUTP 1.12018f
C306 OUTM IREF 3.58234f
C307 OUTP VSS 3.37309f
C308 VDD VCM 1.70853f
C309 a_163000_916100# VDD 2.60143f
C310 a_161400_1209400# VSS 0.85953f
C311 a_166200_870200# VSS 3.15161f
C314 a_202600_71400# VBP 0.28783f
C315 a_166200_473000# OUTM 3.0363f
C319 a_200200_868700# IREF 0.28651f
C321 a_202600_217600# VBN 0.64513f
C322 a_158500_329400# OUTP 3.64537f
C323 a_161400_1209400# a_158500_329400# 0.33832f
C325 a_163000_528900# VCM 0.32256f
C326 a_163000_916100# a_163000_528900# 1.01451f
C333 a_239000_71400# OUTM 0.57302f
C338 a_166200_71400# OUTP 0.28651f
C340 VBN INN 0.28651f
C341 a_163000_868700# VDD 3.10699f
C345 a_158500_217600# VSS 1.14604f
C348 VDD VBP 2.57859f
C349 OUTP IREF 2.8025f
C350 a_161400_1209400# IREF 0.28651f
C352 a_166200_870200# IREF 0.28651f
C353 a_202600_71400# VBN 0.91104f
C354 a_166200_473000# OUTP 1.61283f
C357 a_161400_1209400# a_166200_473000# 0.33832f
C361 a_158500_329400# a_158500_217600# 0.64513f
C362 a_163000_528900# a_163000_868700# 1.14604f
C363 a_163000_916100# a_200200_868700# 0.9677f
C364 a_202600_217600# INP 0.32256f
C365 a_158500_329400# VSS 6.87664f
C367 a_163000_528900# VBP 0.28651f
C374 a_239000_71400# OUTP 0.41728f
C378 a_274600_868700# VDD 2.7659f
C380 a_166200_71400# VSS 1.99514f
C382 INP INN 0.28651f
C383 a_163000_868700# OUTM 1.71906f
C385 a_158500_217600# IREF 0.57302f
C389 VSS IREF 12.6008f
C390 OUTM VBP 1.05733f
C391 VDD VBN 0.28651f
C393 a_163000_528900# a_274600_868700# 1.21815f
C394 a_163000_916100# a_166200_870200# 0.32256f
C395 a_163000_868700# a_200200_868700# 1.45622f
C398 a_202600_71400# INP 0.418f
C399 a_166200_473000# VSS 5.5162f
C404 a_202600_217600# INN 0.32256f
C405 a_158500_329400# IREF 2.46688f
C409 a_158500_329400# a_166200_473000# 1.03869f
C411 INN 0 40.6609f
C412 INP 0 52.2652f
C413 VBN 0 47.9744f
C414 VBP 0 95.1364f
C415 VCM 0 60.756f
C416 IREF 0 0.32231p
C417 VSS 0 0.49783p
C418 OUTP 0 0.49053p
C419 OUTM 0 0.45422p
C420 VDD 0 0.57909p
C421 a_239000_71400# 0 24.9066f ; **FLOATING
C422 a_202600_71400# 0 26.7387f ; **FLOATING
C423 a_166200_71400# 0 34.9794f ; **FLOATING
C424 a_202600_217600# 0 71.3632f ; **FLOATING
C425 a_158500_217600# 0 27.364f ; **FLOATING
C426 a_158500_401200# 0 0.13874p ; **FLOATING
C427 a_166200_870200# 0 49.2058f ; **FLOATING
C428 a_274600_868700# 0 69.6143f ; **FLOATING
C429 a_200200_868700# 0 71.0994f ; **FLOATING
C430 a_163000_868700# 0 77.3224f ; **FLOATING
C431 a_163000_528900# 0 0.72663p ; **FLOATING
C432 a_163000_916100# 0 54.6626f ; **FLOATING
C434 a_166200_473000# 0 0.20511p ; **FLOATING
C436 a_158500_329400# 0 0.17901p ; **FLOATING
C593 a_161400_1209400# 0 0.16107p ; **FLOATING
MVCRPN a_158500_329400# VDD a_161400_1209400# VSS N W=2.5u L=51.218u M=1 AD=11.25p AS=11.25p PD=14u PS=14u
MVCRMN a_166200_473000# VDD a_161400_1209400# VSS N W=2.5u L=51.218u M=1 AD=11.25p AS=11.25p PD=14u PS=14u
.ends ota_telescopic_cm2p5
