.model capsense_phase_gen_cosim d_cosim simulation="/tmp/capsense_phase_runtime/runtime/lib/ngspice/ivlng.so" sim_args=["/tmp/capsense_integrated/simulation/capsense_phase_gen.vvp"] lib_args=["/tmp/capsense_phase_runtime/runtime/lib/libvvp.so" "/tmp/capsense_phase_runtime/runtime/lib/ngspice/ivlng.vpi" "/tmp/capsense_phase_runtime/simulation/phase_v1_vvp.log"]
.model capsense_adc adc_bridge(in_low=2.5 in_high=2.5)
.model capsense_dac dac_bridge(out_low=0 out_high=5 out_undef=2.5 input_load=1p t_rise=1u t_fall=1u)
